* XNOR2 — XNOR: K1 gera !A; K2 escolhe A (B energizado) ou !A
* família discrete_relay, canto típico (VDD 5 V, 23 °C; modelos RELAY: spice/G5V-1.lib, DIODE: spice/1N4148.lib)
* gerado por fr4lane-cellsim --export; rodar: ngspice -b XNOR2.cir (imprime as medidas e grava XNOR2.dat)
*
* entradas no nível de pior caso: alto = 5 V, baixo = 0 V; Y leva 8 carga(s) INV.A
* saída: 1 se >= 4.5 V, 0 se <= 0.5 V
*
* vetores de teste (medida: valor esperado):
*   0-50000 µs  A=0 B=0  ->  s_Y_0: Y=1
*   50000-100000 µs  A=0 B=1  ->  s_Y_1: Y=0
*   100000-150000 µs  A=1 B=0  ->  s_Y_2: Y=0
*   150000-200000 µs  A=1 B=1  ->  s_Y_3: Y=1
*   200000-250000 µs  A=0 B=0  ->  s_Y_4: Y=1
*
* fr4lane-cellsim: canto típico
.temp 23
.param kup=1 kb=1
.param kcoil=1.0
* Relé SPDT de 5 V — modelo comportamental para a simulação analógica (fr4lane-cellsim)
*
* Um relé é mecânico e não tem modelo SPICE de fabricante. Este segue a ficha do
* Omron G5V-1 (5 VDC), um relé SPDT de sinal com bobina de cerca de 30 mA, como o
* da família, sempre do lado do pior caso:
*   bobina 167 Ω (30 mA a 5 V); kcoil escala a resistência (tolerância e o
*   aquecimento do cobre, +0,39 %/°C), e o canto o define;
*   atraca com 21,8 mA (80 % da tensão nominal na bobina no limite de +10 %:
*   4 V / 183,7 Ω, o máximo da ficha) e solta abaixo de 2,7 mA (10 %: 0,5 V /
*   183,7 Ω, o mínimo da ficha). O relé atraca pela corrente (ampère-espiras),
*   então esses limiares não mudam com a temperatura;
*   os contatos mudam ~5 ms depois de a corrente cruzar o limiar (o tempo máximo
*   de operação e de liberação da ficha), com inércia magnética/mecânica na
*   bobina (RC de 0,4 ms) e repique aleatório dos contatos (bounce de ~0,4 a
*   0,9 ms sorteado por instância via unif, controlado por .param bounce=1);
*   contato fechado 0,1 Ω (resistência de contato máxima), aberto 1 GΩ.
*
* Pinos na convenção do fr4lane: bobina c1 (+) e c2, contato comum, NA e NF.
.param bounce=1
.subckt G5V1 c1 c2 com no nc tb1={unif(0.18m, 0.35)} tb2={unif(0.38m, 0.35)} tb3={unif(0.62m, 0.35)}
Vs  c1 cm 0
Rc  cm c2 {167*kcoil}
Bs  s  0  V = 1000 * i(Vs)
Rlp s  sm 400
Clp sm 0  1u
Vad vp 0  1
Sa  vp arm sm 0 SWARM
Ra  arm 0 50
T0  arm 0 d0 0 Z0=50 TD=4.3m
R0  d0  0 50
B0  u0  0 V = 2 * v(d0)
T1  u0  0 d1 0 Z0=50 TD={tb1}
R1  d1  0 50
T2  u0  0 d2 0 Z0=50 TD={tb2}
R2  d2  0 50
T3  u0  0 d3 0 Z0=50 TD={tb3}
R3  d3  0 50
Bno cno 0 V = v(u0) * (1 - bounce * (v(d1) - v(d2)) * v(d3))
Bnc cnc 0 V = (1 - v(u0)) * (1 - bounce * ((1 - v(d1)) - (1 - v(d2))) * (1 - v(d3)))
Sno com no cno 0 SWC
Snc com nc cnc 0 SWC
.model SWARM SW(VT=12.25 VH=9.55 RON=0.01 ROFF=1G)
.model SWC   SW(VT=0.5   VH=0.1  RON=0.1  ROFF=1G)
.ends G5V1
.model DIODE D(IS=4.352E-9 N=1.906 BV=110 IBV=0.0001 RS=0.6458 CJO=7.048E-13 VJ=0.869 M=0.03 FC=0.5 TT=3.48E-9)
.subckt XNOR2 A B Y VDD GND
XK1 A GND n GND VDD G5V1
XK2 B GND Y A n G5V1
D1 GND A DIODE
D2 GND B DIODE
.ends XNOR2
.subckt INV A Y VDD GND
XK1 A GND Y GND VDD G5V1
D1 GND A DIODE
.ends INV
VDD vdd 0 5
V_A in_A 0 PWL(0 0 0.1 0 0.10001 5 0.2 5 0.20001 0)
V_B in_B 0 PWL(0 0 0.05 0 0.05001 5 0.1 5 0.10001 0 0.15 0 0.15001 5 0.2 5 0.20001 0)
Xdut in_A in_B out_Y vdd 0 XNOR2
Xld_out_Y_0 out_Y ld_out_Y_0_Y vdd 0 INV
Xld_out_Y_1 out_Y ld_out_Y_1_Y vdd 0 INV
Xld_out_Y_2 out_Y ld_out_Y_2_Y vdd 0 INV
Xld_out_Y_3 out_Y ld_out_Y_3_Y vdd 0 INV
Xld_out_Y_4 out_Y ld_out_Y_4_Y vdd 0 INV
Xld_out_Y_5 out_Y ld_out_Y_5_Y vdd 0 INV
Xld_out_Y_6 out_Y ld_out_Y_6_Y vdd 0 INV
Xld_out_Y_7 out_Y ld_out_Y_7_Y vdd 0 INV
.tran 0.0001 0.25
.control
run
linearize
set wr_singlescale
set wr_vecnames
wrdata XNOR2.dat v(in_A) v(in_B) v(out_Y)
meas tran s_Y_0 FIND v(out_Y) AT=0.0475
meas tran l_Y_0 FIND v(ld_out_Y_0_Y) AT=0.0475
meas tran s_Y_1 FIND v(out_Y) AT=0.0975
meas tran l_Y_1 FIND v(ld_out_Y_0_Y) AT=0.0975
meas tran d_Y_1 TRIG AT=0.05 TARG v(out_Y) VAL=2.5 TD=0.05 CROSS=1
meas tran s_Y_2 FIND v(out_Y) AT=0.1475
meas tran l_Y_2 FIND v(ld_out_Y_0_Y) AT=0.1475
meas tran s_Y_3 FIND v(out_Y) AT=0.1975
meas tran l_Y_3 FIND v(ld_out_Y_0_Y) AT=0.1975
meas tran d_Y_3 TRIG AT=0.15 TARG v(out_Y) VAL=2.5 TD=0.15 CROSS=1
meas tran s_Y_4 FIND v(out_Y) AT=0.2475
meas tran l_Y_4 FIND v(ld_out_Y_0_Y) AT=0.2475
quit
.endc
.end
