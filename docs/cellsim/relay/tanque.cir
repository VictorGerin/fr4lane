* tanque — circuito sintetizado pelo pcbflow (15 células: DFFR, INV, MUX2, NAND2, OR2, XNOR2, XOR2; 64 componentes)
* família discrete_relay, canto típico (VDD 5 V, 23 °C)
* gerado por pcbflow-cellsim --design tanque --export; rodar: ngspice -b tanque.cir
*
* entradas no nível de pior caso: alto = 5 V, baixo = 0 V; cada saída leva uma carga de referência
* saída: 1 se >= 4.5 V, 0 se <= 0.5 V
*
* vetores de teste (medida: valor esperado):
*   vetor 0 (0-50000 µs): clk=0 rst_n=0 nivel_baixo=0 nivel_alto=0  ->  s_estado_0__0: estado[0]=0, s_estado_1__0: estado[1]=0, s_bomba_0: bomba=0
*   vetor 1 (50000-100000 µs): clk=0 rst_n=1 nivel_baixo=0 nivel_alto=0  ->  s_estado_0__1: estado[0]=0, s_estado_1__1: estado[1]=0, s_bomba_1: bomba=0
*   vetor 2 (100000-150000 µs): clk=1 rst_n=1 nivel_baixo=0 nivel_alto=0  ->  s_estado_0__2: estado[0]=1, s_estado_1__2: estado[1]=0, s_bomba_2: bomba=1
*   vetor 3 (150000-200000 µs): clk=0 rst_n=1 nivel_baixo=1 nivel_alto=0  ->  s_estado_0__3: estado[0]=1, s_estado_1__3: estado[1]=0, s_bomba_3: bomba=1
*   vetor 4 (200000-250000 µs): clk=1 rst_n=1 nivel_baixo=1 nivel_alto=0  ->  s_estado_0__4: estado[0]=1, s_estado_1__4: estado[1]=0, s_bomba_4: bomba=1
*   vetor 5 (250000-300000 µs): clk=0 rst_n=1 nivel_baixo=0 nivel_alto=1  ->  s_estado_0__5: estado[0]=1, s_estado_1__5: estado[1]=0, s_bomba_5: bomba=1
*   vetor 6 (300000-350000 µs): clk=1 rst_n=1 nivel_baixo=0 nivel_alto=1  ->  s_estado_0__6: estado[0]=0, s_estado_1__6: estado[1]=1, s_bomba_6: bomba=0
*   vetor 7 (350000-400000 µs): clk=0 rst_n=1 nivel_baixo=1 nivel_alto=1  ->  s_estado_0__7: estado[0]=0, s_estado_1__7: estado[1]=1, s_bomba_7: bomba=0
*   vetor 8 (400000-450000 µs): clk=1 rst_n=1 nivel_baixo=1 nivel_alto=1  ->  s_estado_0__8: estado[0]=0, s_estado_1__8: estado[1]=1, s_bomba_8: bomba=0
*   vetor 9 (450000-500000 µs): clk=0 rst_n=1 nivel_baixo=0 nivel_alto=0  ->  s_estado_0__9: estado[0]=0, s_estado_1__9: estado[1]=1, s_bomba_9: bomba=0
*   vetor 10 (500000-550000 µs): clk=1 rst_n=1 nivel_baixo=0 nivel_alto=0  ->  s_estado_0__10: estado[0]=1, s_estado_1__10: estado[1]=1, s_bomba_10: bomba=0
*   vetor 11 (550000-600000 µs): clk=0 rst_n=1 nivel_baixo=1 nivel_alto=0  ->  s_estado_0__11: estado[0]=1, s_estado_1__11: estado[1]=1, s_bomba_11: bomba=0
*   vetor 12 (600000-650000 µs): clk=1 rst_n=1 nivel_baixo=1 nivel_alto=0  ->  s_estado_0__12: estado[0]=1, s_estado_1__12: estado[1]=1, s_bomba_12: bomba=0
*   vetor 13 (650000-700000 µs): clk=0 rst_n=1 nivel_baixo=0 nivel_alto=1  ->  s_estado_0__13: estado[0]=1, s_estado_1__13: estado[1]=1, s_bomba_13: bomba=0
*   vetor 14 (700000-750000 µs): clk=1 rst_n=1 nivel_baixo=0 nivel_alto=1  ->  s_estado_0__14: estado[0]=0, s_estado_1__14: estado[1]=0, s_bomba_14: bomba=0
*   vetor 15 (750000-800000 µs): clk=0 rst_n=1 nivel_baixo=1 nivel_alto=1  ->  s_estado_0__15: estado[0]=0, s_estado_1__15: estado[1]=0, s_bomba_15: bomba=0
*   vetor 16 (800000-850000 µs): clk=1 rst_n=1 nivel_baixo=1 nivel_alto=1  ->  s_estado_0__16: estado[0]=0, s_estado_1__16: estado[1]=0, s_bomba_16: bomba=0
*
* pcbflow-cellsim: canto típico
.temp 23
.param kup=1 kb=1
.param kcoil=1.0
* Relé SPDT de 5 V — modelo comportamental para a simulação analógica (pcbflow-cellsim)
*
* Um relé é mecânico e não tem modelo SPICE de fabricante. Este segue a ficha do
* Omron G5V-1 (5 VDC), um relé SPDT de sinal com bobina de cerca de 30 mA, como o
* da família, sempre do lado do pior caso:
*   bobina 167 Ω (30 mA a 5 V); kcoil escala a resistência (tolerância e o
*   aquecimento do cobre, +0,39 %/°C), e o canto o define;
*   atraca com 21,8 mA (80 % da tensão nominal na bobina no limite de +10 %:
*   4 V / 183,7 Ω, o máximo da ficha) e solta abaixo de 2,7 mA (10 %: 0,5 V /
*   183,7 Ω, o mínimo da ficha). O relé atraca pela corrente (ampère-espiras),
*   então esses limiares não mudam com a temperatura;
*   os contatos mudam ~5 ms depois de a corrente cruzar o limiar (o tempo máximo
*   de operação e de liberação da ficha), com inércia magnética/mecânica na
*   bobina (RC de 0,4 ms) e repique aleatório dos contatos (bounce de ~0,4 a
*   0,9 ms sorteado por instância via unif, controlado por .param bounce=1);
*   contato fechado 0,1 Ω (resistência de contato máxima), aberto 1 GΩ.
*
* Pinos na convenção do pcbflow: bobina c1 (+) e c2, contato comum, NA e NF.
.param bounce=1
.subckt G5V1 c1 c2 com no nc tb1={unif(0.18m, 0.2)} tb2={unif(0.38m, 0.2)} tb3={unif(0.62m, 0.2)}
Vs  c1 cm 0
Rc  cm c2 {167*kcoil}
Bs  s  0  V = 1000 * i(Vs)
Rlp s  sm 400
Clp sm 0  1u
Vad vp 0  1
Sa  vp arm sm 0 SWARM
Ra  arm 0 50
T0  arm 0 d0 0 Z0=50 TD=4.0m
R0  d0  0 50
B0  u0  0 V = 2 * v(d0)
T1  u0  0 d1 0 Z0=50 TD={tb1}
R1  d1  0 50
T2  u0  0 d2 0 Z0=50 TD={tb2}
R2  d2  0 50
T3  u0  0 d3 0 Z0=50 TD={tb3}
R3  d3  0 50
Bno cno 0 V = v(u0) * (1 - bounce * (v(d1) - v(d2)) * v(d3))
Bnc cnc 0 V = (1 - v(u0)) * (1 - bounce * ((1 - v(d1)) - (1 - v(d2))) * (1 - v(d3)))
Sno com no cno 0 SWC
Snc com nc cnc 0 SWC
.model SWARM SW(VT=12.25 VH=9.55 RON=0.01 ROFF=1G)
.model SWC   SW(VT=0.5   VH=0.1  RON=0.1  ROFF=1G)
.ends G5V1
.model DIODE D(IS=4.352E-9 N=1.906 BV=110 IBV=0.0001 RS=0.6458 CJO=7.048E-13 VJ=0.869 M=0.03 FC=0.5 TT=3.48E-9)
.subckt DFFR D C R Q VDD GND
XK1 C GND X1 Q1 D G5V1
XK5 R GND Y1 X1 GND G5V1
XK2 Y1 GND Q1 VDD GND G5V1
XK3 C GND X2 Q1 Q G5V1
XK6 R GND Y2 X2 GND G5V1
XK4 Y2 GND Q VDD GND G5V1
D1 GND C DIODE
D2 GND R DIODE
D3 GND Y1 DIODE
D4 GND Y2 DIODE
.ends DFFR
.subckt INV A Y VDD GND
XK1 A GND Y GND VDD G5V1
D1 GND A DIODE
.ends INV
.subckt MUX2 A B S Y VDD GND
XK1 S GND Y B A G5V1
D1 GND S DIODE
.ends MUX2
.subckt NAND2 A B Y VDD GND
XK1 A GND n GND VDD G5V1
XK2 B GND Y n VDD G5V1
D1 GND A DIODE
D2 GND B DIODE
.ends NAND2
.subckt OR2 A B Y VDD GND
XK1 A GND n VDD GND G5V1
XK2 B GND Y VDD n G5V1
D1 GND A DIODE
D2 GND B DIODE
.ends OR2
.subckt XNOR2 A B Y VDD GND
XK1 A GND n GND VDD G5V1
XK2 B GND Y A n G5V1
D1 GND A DIODE
D2 GND B DIODE
.ends XNOR2
.subckt XOR2 A B Y VDD GND
XK1 A GND n GND VDD G5V1
XK2 B GND Y n A G5V1
D1 GND A DIODE
D2 GND B DIODE
.ends XOR2
VDD vdd 0 5
V_clk n2 0 PWL(0 0 0.1 0 0.10001 5 0.15 5 0.15001 0 0.2 0 0.20001 5 0.25 5 0.25001 0 0.3 0 0.30001 5 0.35 5 0.35001 0 0.4 0 0.40001 5 0.45 5 0.45001 0 0.5 0 0.50001 5 0.55 5 0.55001 0 0.6 0 0.60001 5 0.65 5 0.65001 0 0.7 0 0.70001 5 0.75 5 0.75001 0 0.8 0 0.80001 5)
V_rst_n n3 0 PWL(0 0 0.05 0 0.05001 5)
V_nivel_baixo n4 0 PWL(0 0 0.15 0 0.15001 5 0.25 5 0.25001 0 0.35 0 0.35001 5 0.45 5 0.45001 0 0.55 0 0.55001 5 0.65 5 0.65001 0 0.75 0 0.75001 5)
V_nivel_alto n5 0 PWL(0 0 0.25 0 0.25001 5 0.45 5 0.45001 0 0.65 0 0.65001 5)
XU1 n4 n6 vdd 0 INV
XU2 n7 n8 vdd 0 INV
XU3 n9 n8 n10 vdd 0 NAND2
XU4 n10 n11 vdd 0 INV
XU5 n9 n8 n12 vdd 0 OR2
XU6 n10 n12 n5 n13 vdd 0 MUX2
XU7 n9 n7 n14 vdd 0 XOR2
XU8 n6 n14 n15 vdd 0 OR2
XU9 n13 n14 n16 vdd 0 NAND2
XU10 n13 n15 n17 vdd 0 NAND2
XU11 n9 n17 n18 vdd 0 XNOR2
XU12 n7 n17 n19 vdd 0 NAND2
XU13 n16 n19 n20 vdd 0 NAND2
XFF1 n18 n2 n3 n9 vdd 0 DFFR
XFF2 n20 n2 n3 n7 vdd 0 DFFR
Xld_estado_0_ n9 ldo_estado_0__Y vdd 0 INV
Xld_estado_1_ n7 ldo_estado_1__Y vdd 0 INV
Xld_bomba n11 ldo_bomba_Y vdd 0 INV
.tran 0.0001 0.85
.control
run
linearize
set wr_singlescale
set wr_vecnames
wrdata tanque.dat v(n2) v(n3) v(n4) v(n5) v(n9) v(n7) v(n11)
meas tran s_estado_0__0 FIND v(n9) AT=0.0475
meas tran s_estado_1__0 FIND v(n7) AT=0.0475
meas tran s_bomba_0 FIND v(n11) AT=0.0475
meas tran s_estado_0__1 FIND v(n9) AT=0.0975
meas tran s_estado_1__1 FIND v(n7) AT=0.0975
meas tran s_bomba_1 FIND v(n11) AT=0.0975
meas tran s_estado_0__2 FIND v(n9) AT=0.1475
meas tran t_estado_0__2 WHEN v(n9)=2.5 CROSS=LAST FROM=0.1 TO=0.15
meas tran s_estado_1__2 FIND v(n7) AT=0.1475
meas tran s_bomba_2 FIND v(n11) AT=0.1475
meas tran t_bomba_2 WHEN v(n11)=2.5 CROSS=LAST FROM=0.1 TO=0.15
meas tran s_estado_0__3 FIND v(n9) AT=0.1975
meas tran s_estado_1__3 FIND v(n7) AT=0.1975
meas tran s_bomba_3 FIND v(n11) AT=0.1975
meas tran s_estado_0__4 FIND v(n9) AT=0.2475
meas tran s_estado_1__4 FIND v(n7) AT=0.2475
meas tran s_bomba_4 FIND v(n11) AT=0.2475
meas tran s_estado_0__5 FIND v(n9) AT=0.2975
meas tran s_estado_1__5 FIND v(n7) AT=0.2975
meas tran s_bomba_5 FIND v(n11) AT=0.2975
meas tran s_estado_0__6 FIND v(n9) AT=0.3475
meas tran t_estado_0__6 WHEN v(n9)=2.5 CROSS=LAST FROM=0.3 TO=0.35
meas tran s_estado_1__6 FIND v(n7) AT=0.3475
meas tran t_estado_1__6 WHEN v(n7)=2.5 CROSS=LAST FROM=0.3 TO=0.35
meas tran s_bomba_6 FIND v(n11) AT=0.3475
meas tran t_bomba_6 WHEN v(n11)=2.5 CROSS=LAST FROM=0.3 TO=0.35
meas tran s_estado_0__7 FIND v(n9) AT=0.3975
meas tran s_estado_1__7 FIND v(n7) AT=0.3975
meas tran s_bomba_7 FIND v(n11) AT=0.3975
meas tran s_estado_0__8 FIND v(n9) AT=0.4475
meas tran s_estado_1__8 FIND v(n7) AT=0.4475
meas tran s_bomba_8 FIND v(n11) AT=0.4475
meas tran s_estado_0__9 FIND v(n9) AT=0.4975
meas tran s_estado_1__9 FIND v(n7) AT=0.4975
meas tran s_bomba_9 FIND v(n11) AT=0.4975
meas tran s_estado_0__10 FIND v(n9) AT=0.5475
meas tran t_estado_0__10 WHEN v(n9)=2.5 CROSS=LAST FROM=0.5 TO=0.55
meas tran s_estado_1__10 FIND v(n7) AT=0.5475
meas tran s_bomba_10 FIND v(n11) AT=0.5475
meas tran s_estado_0__11 FIND v(n9) AT=0.5975
meas tran s_estado_1__11 FIND v(n7) AT=0.5975
meas tran s_bomba_11 FIND v(n11) AT=0.5975
meas tran s_estado_0__12 FIND v(n9) AT=0.6475
meas tran s_estado_1__12 FIND v(n7) AT=0.6475
meas tran s_bomba_12 FIND v(n11) AT=0.6475
meas tran s_estado_0__13 FIND v(n9) AT=0.6975
meas tran s_estado_1__13 FIND v(n7) AT=0.6975
meas tran s_bomba_13 FIND v(n11) AT=0.6975
meas tran s_estado_0__14 FIND v(n9) AT=0.7475
meas tran t_estado_0__14 WHEN v(n9)=2.5 CROSS=LAST FROM=0.7 TO=0.75
meas tran s_estado_1__14 FIND v(n7) AT=0.7475
meas tran t_estado_1__14 WHEN v(n7)=2.5 CROSS=LAST FROM=0.7 TO=0.75
meas tran s_bomba_14 FIND v(n11) AT=0.7475
meas tran s_estado_0__15 FIND v(n9) AT=0.7975
meas tran s_estado_1__15 FIND v(n7) AT=0.7975
meas tran s_bomba_15 FIND v(n11) AT=0.7975
meas tran s_estado_0__16 FIND v(n9) AT=0.8475
meas tran s_estado_1__16 FIND v(n7) AT=0.8475
meas tran s_bomba_16 FIND v(n11) AT=0.8475
quit
.endc
.end
