* DLAT — latch D transparente com E = 1 (4 NOR2 CTL + inversor)
* família discrete_ctl, canto típico (VDD 5 V, 27 °C; modelos CORE: spice/FERRITE.lib, NPN: spice/BC548B.lib)
* gerado por pcbflow-cellsim --export; rodar: ngspice -b DLAT.cir (imprime as medidas e grava DLAT.dat)
*
* entradas no nível de pior caso: alto = 3.6 V, baixo = 0.4 V; Q leva 4 carga(s) INV.A
* saída: 1 se >= 2.75 V, 0 se <= 0.5 V
*
* vetores de teste (medida: valor esperado):
*   E ligado até 80 µs; D muda em 20, 40, 60, 100 e 120 µs
*   18 µs (transparente)  ->  s_0: Q=0
*   38 µs (transparente)  ->  s_1: Q=1
*   58 µs (transparente)  ->  s_2: Q=0
*   78 µs (transparente)  ->  s_3: Q=1
*   118 µs (travado)  ->  s_4: Q=1
*   138 µs (travado)  ->  s_5: Q=1
*
* pcbflow-cellsim: canto típico
.temp 27
.param kup=1 kb=1
.param kcore=1.0 kic=1.0
* Núcleo toroidal de ferrite CTL — modelo comportamental para simulação analógica (pcbflow-cellsim)
*
* Um núcleo de ferrite de laço retangular (square-loop) para lógica CTL possui
* três enrolamentos de comando (W1 e W2 no sentido positivo, +N espiras; WB no
* sentido oposto de inibição/bias, -N espiras) e um enrolamento de saída/sense S
* que excita a base do transistor NPN regenerador (BC548).
*
* Física modelada:
*   - Resistência CC de cada enrolamento: 10 Ω (escalada por kcore). A corrente
*     de entrada é definida pelos resistores externos de 10 kΩ (~0,25 a 0,5 mA por
*     unidade de corrente I0 conforme o fan-out da porta anterior);
*   - Força magnetomotriz (FMM) líquida normalizada em mA:
*       Immf = 1000 * (I(W1) + I(W2) - I(WB))
*     Em NOR2/INV (WB=0), qualquer entrada alta gera >= 0,22 mA. Em NAND2, WB recebe
*     uma corrente de polarização (bias) de VDD (via 27 kΩ) que cancela magneticamente
*     o fluxo de uma única entrada alta, exigindo coincidência de corrente nas duas
*     entradas (A=1 e B=1) para vencer a coercividade e comutar um único núcleo + 1 NPN;
*   - Inércia de comutação de parede de domínio magnético (tempo de chaveamento
*     de Peaker τ_sw ≈ 120 ns, modelado por Rmag=120 Ω e Cmag=1 nF) e laço de
*     histerese retangular (SWCORE com limiar coercivo Ic = 0,12 mA ± 0,02 mA,
*     escalado por kic conforme a temperatura do ferrite);
*   - Acoplamento de saída S para a base do transistor regenerador através da
*     impedância equivalente do enrolamento secundário (Rs = 10 kΩ).
*
* Pinos na convenção do pcbflow: w1, w2, wb, s, gnd.
.param kcore=1.0 kic=1.0
.subckt FCORE w1 w2 wb s gnd
Vw1  w1  w1m 0
Rw1  w1m gnd {10*kcore}
Vw2  w2  w2m 0
Rw2  w2m gnd {10*kcore}
Vwb  wb  wbm 0
Rwb  wbm gnd {10*kcore}
Bmmf mmf gnd V = 1000 * (i(Vw1) + i(Vw2) - i(Vwb)) / kic
Rmag mmf flx 120
Cmag flx gnd 1n
Vdrv vp  gnd 5.0
Sc   vp  sc  flx gnd SWCORE
Rsc  sc  gnd 100k
Rs   sc  s   {10k*kcore}
.model SWCORE SW(VT=0.12 VH=0.02 RON=10 ROFF=100MEG)
.ends FCORE
.model NPN NPN(Is=7.049f Xti=3 Eg=1.11 Vaf=54.76 Bf=250 Ise=78.17f Ne=1.479 Ikf=24.96m Nkf=.5381 Xtb=1.5 Br=1.2 Isc=27.51f Nc=1.775 Ikr=3.321 Rc=.9706 Cjc=4.25p Mjc=.3147 Vjc=.5697 Fc=.5 Cje=11.5p Mje=.6715 Vje=.5 Tr=10n Tf=410.7p Itf=1.12 Xtf=26.19 Vtf=10)
.subckt INV A Y VDD GND
RL VDD Y {1000*kup}
R1 A w1 {10000*kb}
XT1 w1 GND GND b1 GND FCORE
Q1 Y b1 GND NPN
.ends INV
.subckt NOR2 A B Y VDD GND
RL VDD Y {1000*kup}
R1 A w1 {10000*kb}
R2 B w2 {10000*kb}
XT1 w1 w2 GND b1 GND FCORE
Q1 Y b1 GND NPN
.ends NOR2
.subckt DLAT D E Q VDD GND
X0 E eb VDD GND INV
X1 D eb r VDD GND NOR2
X2 r eb s VDD GND NOR2
X3 r QN Q VDD GND NOR2
X4 s Q QN VDD GND NOR2
.ends DLAT
VDD vdd 0 5
V_E in_E 0 PWL(0 3.6 8e-05 3.6 8.0002e-05 0.4)
V_D in_D 0 PWL(0 0.4 2e-05 0.4 2.0002e-05 3.6 4e-05 3.6 4.0002e-05 0.4 6e-05 0.4 6.0002e-05 3.6 0.0001 3.6 0.000100002 0.4 0.00012 0.4 0.000120002 3.6)
Xdut in_D in_E out_Q vdd 0 DLAT
Xld_out_Q_0 out_Q ld_out_Q_0_Y vdd 0 INV
Xld_out_Q_1 out_Q ld_out_Q_1_Y vdd 0 INV
Xld_out_Q_2 out_Q ld_out_Q_2_Y vdd 0 INV
Xld_out_Q_3 out_Q ld_out_Q_3_Y vdd 0 INV
.tran 4e-08 0.00014
.control
run
linearize
set wr_singlescale
set wr_vecnames
wrdata DLAT.dat v(in_E) v(in_D) v(out_Q)
meas tran s_0 FIND v(out_Q) AT=1.8e-05
meas tran s_1 FIND v(out_Q) AT=3.8e-05
meas tran s_2 FIND v(out_Q) AT=5.8e-05
meas tran s_3 FIND v(out_Q) AT=7.8e-05
meas tran s_4 FIND v(out_Q) AT=0.000118
meas tran s_5 FIND v(out_Q) AT=0.000138
meas tran dq_0 TRIG AT=2e-05 TARG v(out_Q) VAL=1.5 TD=2e-05 CROSS=1
meas tran dq_1 TRIG AT=4e-05 TARG v(out_Q) VAL=1.5 TD=4e-05 CROSS=1
meas tran dq_2 TRIG AT=6e-05 TARG v(out_Q) VAL=1.5 TD=6e-05 CROSS=1
quit
.endc
.end
