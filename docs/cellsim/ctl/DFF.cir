* DFF — flip-flop D, borda de subida (portas NOR2 + INV em lógica CTL)
* família discrete_ctl, canto típico (VDD 5 V, 27 °C; modelos CORE: spice/FERRITE.lib, NPN: spice/BC548B.lib)
* gerado por pcbflow-cellsim --export; rodar: ngspice -b DFF.cir (imprime as medidas e grava DFF.dat)
*
* entradas no nível de pior caso: alto = 3.6 V, baixo = 0.4 V; Q leva 4 carga(s) INV.A
* saída: 1 se >= 2.75 V, 0 se <= 0.5 V
*
* vetores de teste (medida: valor esperado):
*   borda de subida 1 em 20 µs: D=1 (muda 5 µs antes)  ->  q_0: Q=1
*   borda de subida 2 em 40 µs: D=0 (muda 5 µs antes)  ->  q_1: Q=0
*   borda de subida 3 em 60 µs: D=1 (muda 5 µs antes)  ->  q_2: Q=1
*   borda de subida 4 em 80 µs: D=1 (muda 5 µs antes)  ->  q_3: Q=1
*   borda de subida 5 em 100 µs: D=0 (muda 5 µs antes)  ->  q_4: Q=0
*   borda de subida 6 em 120 µs: D=0 (muda 5 µs antes)  ->  q_5: Q=0
*   borda de subida 7 em 140 µs: D=1 (muda 5 µs antes)  ->  q_6: Q=1
*   borda de subida 8 em 160 µs: D=0 (muda 5 µs antes)  ->  q_7: Q=0
*   borda de subida 9 em 180 µs: D=1 (muda 5 µs antes)  ->  q_8: Q=1
*   borda de subida 10 em 200 µs: D=1 (muda 5 µs antes)  ->  q_9: Q=1
*   borda de subida 11 em 220 µs: D=1 (muda 5 µs antes)  ->  q_10: Q=1
*   borda de subida 12 em 240 µs: D=0 (muda 5 µs antes)  ->  q_11: Q=0
*
* pcbflow-cellsim: canto típico
.temp 27
.param kup=1 kb=1
.param kcore=1.0 kic=1.0
* Núcleo toroidal de ferrite CTL — modelo comportamental para simulação analógica (pcbflow-cellsim)
*
* Um núcleo de ferrite de laço retangular (square-loop) para lógica CTL possui
* três enrolamentos de comando (W1 e W2 no sentido positivo, +N espiras; WB no
* sentido oposto de inibição/bias, -N espiras) e um enrolamento de saída/sense S
* que excita a base do transistor NPN regenerador (BC548).
*
* Física modelada:
*   - Resistência CC de cada enrolamento: 10 Ω (escalada por kcore). A corrente
*     de entrada é definida pelos resistores externos de 10 kΩ (~0,25 a 0,5 mA por
*     unidade de corrente I0 conforme o fan-out da porta anterior);
*   - Força magnetomotriz (FMM) líquida normalizada em mA:
*       Immf = 1000 * (I(W1) + I(W2) - I(WB))
*     Em NOR2/INV (WB=0), qualquer entrada alta gera >= 0,22 mA. Em NAND2, WB recebe
*     uma corrente de polarização (bias) de VDD (via 27 kΩ) que cancela magneticamente
*     o fluxo de uma única entrada alta, exigindo coincidência de corrente nas duas
*     entradas (A=1 e B=1) para vencer a coercividade e comutar um único núcleo + 1 NPN;
*   - Inércia de comutação de parede de domínio magnético (tempo de chaveamento
*     de Peaker τ_sw ≈ 120 ns, modelado por Rmag=120 Ω e Cmag=1 nF) e laço de
*     histerese retangular (SWCORE com limiar coercivo Ic = 0,12 mA ± 0,02 mA,
*     escalado por kic conforme a temperatura do ferrite);
*   - Acoplamento de saída S para a base do transistor regenerador através da
*     impedância equivalente do enrolamento secundário (Rs = 10 kΩ).
*
* Pinos na convenção do pcbflow: w1, w2, wb, s, gnd.
.param kcore=1.0 kic=1.0
.subckt FCORE w1 w2 wb s gnd
Vw1  w1  w1m 0
Rw1  w1m gnd {10*kcore}
Vw2  w2  w2m 0
Rw2  w2m gnd {10*kcore}
Vwb  wb  wbm 0
Rwb  wbm gnd {10*kcore}
Bmmf mmf gnd V = 1000 * (i(Vw1) + i(Vw2) - i(Vwb)) / kic
Rmag mmf flx 120
Cmag flx gnd 1n
Vdrv vp  gnd 5.0
Sc   vp  sc  flx gnd SWCORE
Rsc  sc  gnd 100k
Rs   sc  s   {10k*kcore}
.model SWCORE SW(VT=0.12 VH=0.02 RON=10 ROFF=100MEG)
.ends FCORE
.model NPN NPN(Is=7.049f Xti=3 Eg=1.11 Vaf=54.76 Bf=250 Ise=78.17f Ne=1.479 Ikf=24.96m Nkf=.5381 Xtb=1.5 Br=1.2 Isc=27.51f Nc=1.775 Ikr=3.321 Rc=.9706 Cjc=4.25p Mjc=.3147 Vjc=.5697 Fc=.5 Cje=11.5p Mje=.6715 Vje=.5 Tr=10n Tf=410.7p Itf=1.12 Xtf=26.19 Vtf=10)
.subckt INV A Y VDD GND
RL VDD Y {1000*kup}
R1 A w1 {10000*kb}
XT1 w1 GND GND b1 GND FCORE
Q1 Y b1 GND NPN
.ends INV
.subckt NOR2 A B Y VDD GND
RL VDD Y {1000*kup}
R1 A w1 {10000*kb}
R2 B w2 {10000*kb}
XT1 w1 w2 GND b1 GND FCORE
Q1 Y b1 GND NPN
.ends NOR2
.subckt NOR3 A B C Y VDD GND
RL VDD Y {1000*kup}
R1 A w1 {10000*kb}
R2 B w2 {10000*kb}
R3 C w3 {10000*kb}
XT1 w1 w2 GND b1 GND FCORE
XT2 w3 GND GND b1 GND FCORE
Q1 Y b1 GND NPN
.ends NOR3
.subckt DFF D C Q VDD GND
X0 C ck VDD GND INV
X1 n4 n2 n1 VDD GND NOR2
X2 n1 ck n2 VDD GND NOR2
X3 n2 ck n4 n3 VDD GND NOR3
X4 n3 D n4 VDD GND NOR2
X5 n2 QN Q VDD GND NOR2
X6 Q n3 QN VDD GND NOR2
.ends DFF
VDD vdd 0 5
V_C in_C 0 PULSE(0.4 3.6 2e-05 2e-09 2e-09 9.998e-06 2e-05)
V_D in_D 0 PWL(0 0.4 1.5e-05 0.4 1.5002e-05 3.6 3.5e-05 3.6 3.5002e-05 0.4 5.5e-05 0.4 5.5002e-05 3.6 9.5e-05 3.6 9.5002e-05 0.4 0.000135 0.4 0.000135002 3.6 0.000155 3.6 0.000155002 0.4 0.000175 0.4 0.000175002 3.6 0.000235 3.6 0.000235002 0.4)
Xdut in_D in_C out_Q vdd 0 DFF
Xld_out_Q_0 out_Q ld_out_Q_0_Y vdd 0 INV
Xld_out_Q_1 out_Q ld_out_Q_1_Y vdd 0 INV
Xld_out_Q_2 out_Q ld_out_Q_2_Y vdd 0 INV
Xld_out_Q_3 out_Q ld_out_Q_3_Y vdd 0 INV
.tran 5e-08 0.00026
.control
run
linearize
set wr_singlescale
set wr_vecnames
wrdata DFF.dat v(in_C) v(in_D) v(out_Q)
meas tran q_0 FIND v(out_Q) AT=2.9e-05
meas tran q_1 FIND v(out_Q) AT=4.9e-05
meas tran q_2 FIND v(out_Q) AT=6.9e-05
meas tran q_3 FIND v(out_Q) AT=8.9e-05
meas tran q_4 FIND v(out_Q) AT=0.000109
meas tran q_5 FIND v(out_Q) AT=0.000129
meas tran q_6 FIND v(out_Q) AT=0.000149
meas tran q_7 FIND v(out_Q) AT=0.000169
meas tran q_8 FIND v(out_Q) AT=0.000189
meas tran q_9 FIND v(out_Q) AT=0.000209
meas tran q_10 FIND v(out_Q) AT=0.000229
meas tran q_11 FIND v(out_Q) AT=0.000249
quit
.endc
.end
