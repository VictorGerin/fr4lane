* NOR3 — NOR de 3 entradas CTL (2 núcleos toroidais + 1 NPN)
* família discrete_ctl, canto típico (VDD 5 V, 27 °C; modelos CORE: spice/FERRITE.lib, NPN: spice/BC548B.lib)
* gerado por fr4lane-cellsim --export; rodar: ngspice -b NOR3.cir (imprime as medidas e grava NOR3.dat)
*
* entradas no nível de pior caso: alto = 3.6 V, baixo = 0.4 V; Y leva 4 carga(s) INV.A
* saída: 1 se >= 2.75 V, 0 se <= 0.5 V
*
* vetores de teste (medida: valor esperado):
*   0-20 µs  A=0 B=0 C=0  ->  s_Y_0: Y=1
*   20-40 µs  A=0 B=0 C=1  ->  s_Y_1: Y=0
*   40-60 µs  A=0 B=1 C=0  ->  s_Y_2: Y=0
*   60-80 µs  A=0 B=1 C=1  ->  s_Y_3: Y=0
*   80-100 µs  A=1 B=0 C=0  ->  s_Y_4: Y=0
*   100-120 µs  A=1 B=0 C=1  ->  s_Y_5: Y=0
*   120-140 µs  A=1 B=1 C=0  ->  s_Y_6: Y=0
*   140-160 µs  A=1 B=1 C=1  ->  s_Y_7: Y=0
*   160-180 µs  A=0 B=0 C=0  ->  s_Y_8: Y=1
*
* fr4lane-cellsim: canto típico
.temp 27
.param kup=1 kb=1
.param kcore=1.0 kic=1.0
* Núcleo toroidal de ferrite CTL — modelo comportamental para simulação analógica (fr4lane-cellsim)
*
* Um núcleo de ferrite de laço retangular (square-loop) para lógica CTL possui
* três enrolamentos de comando (W1 e W2 no sentido positivo, +N espiras; WB no
* sentido oposto de inibição/bias, -N espiras) e um enrolamento de saída/sense S
* que excita a base do transistor NPN regenerador (BC548).
*
* Física modelada:
*   - Resistência CC de cada enrolamento: 10 Ω (escalada por kcore). A corrente
*     de entrada é definida pelos resistores externos de 10 kΩ (~0,25 a 0,5 mA por
*     unidade de corrente I0 conforme o fan-out da porta anterior);
*   - Força magnetomotriz (FMM) líquida normalizada em mA:
*       Immf = 1000 * (I(W1) + I(W2) - I(WB))
*     Em NOR2/INV (WB=0), qualquer entrada alta gera >= 0,22 mA. Em NAND2, WB recebe
*     uma corrente de polarização (bias) de VDD (via 27 kΩ) que cancela magneticamente
*     o fluxo de uma única entrada alta, exigindo coincidência de corrente nas duas
*     entradas (A=1 e B=1) para vencer a coercividade e comutar um único núcleo + 1 NPN;
*   - Inércia de comutação de parede de domínio magnético (tempo de chaveamento
*     de Peaker τ_sw ≈ 120 ns, modelado por Rmag=120 Ω e Cmag=1 nF) e laço de
*     histerese retangular (SWCORE com limiar coercivo Ic = 0,12 mA ± 0,02 mA,
*     escalado por kic conforme a temperatura do ferrite);
*   - Acoplamento de saída S para a base do transistor regenerador através da
*     impedância equivalente do enrolamento secundário (Rs = 10 kΩ).
*
* Pinos na convenção do fr4lane: w1, w2, wb, s, gnd.
.param kcore=1.0 kic=1.0
.subckt FCORE w1 w2 wb s gnd
Vw1  w1  w1m 0
Rw1  w1m gnd {10*kcore}
Vw2  w2  w2m 0
Rw2  w2m gnd {10*kcore}
Vwb  wb  wbm 0
Rwb  wbm gnd {10*kcore}
Bmmf mmf gnd V = 1000 * (i(Vw1) + i(Vw2) - i(Vwb)) / kic
Rmag mmf flx 120
Cmag flx gnd 1n
Vdrv vp  gnd 5.0
Sc   vp  sc  flx gnd SWCORE
Rsc  sc  gnd 100k
Rs   sc  s   {10k*kcore}
.model SWCORE SW(VT=0.12 VH=0.02 RON=10 ROFF=100MEG)
.ends FCORE
.model NPN NPN(Is=7.049f Xti=3 Eg=1.11 Vaf=54.76 Bf=250 Ise=78.17f Ne=1.479 Ikf=24.96m Nkf=.5381 Xtb=1.5 Br=1.2 Isc=27.51f Nc=1.775 Ikr=3.321 Rc=.9706 Cjc=4.25p Mjc=.3147 Vjc=.5697 Fc=.5 Cje=11.5p Mje=.6715 Vje=.5 Tr=10n Tf=410.7p Itf=1.12 Xtf=26.19 Vtf=10)
.subckt NOR3 A B C Y VDD GND
RL VDD Y {1000*kup}
R1 A w1 {10000*kb}
R2 B w2 {10000*kb}
R3 C w3 {10000*kb}
XT1 w1 w2 GND b1 GND FCORE
XT2 w3 GND GND b1 GND FCORE
Q1 Y b1 GND NPN
.ends NOR3
.subckt INV A Y VDD GND
RL VDD Y {1000*kup}
R1 A w1 {10000*kb}
XT1 w1 GND GND b1 GND FCORE
Q1 Y b1 GND NPN
.ends INV
VDD vdd 0 5
V_A in_A 0 PWL(0 0.4 8e-05 0.4 8.0002e-05 3.6 0.00016 3.6 0.000160002 0.4)
V_B in_B 0 PWL(0 0.4 4e-05 0.4 4.0002e-05 3.6 8e-05 3.6 8.0002e-05 0.4 0.00012 0.4 0.000120002 3.6 0.00016 3.6 0.000160002 0.4)
V_C in_C 0 PWL(0 0.4 2e-05 0.4 2.0002e-05 3.6 4e-05 3.6 4.0002e-05 0.4 6e-05 0.4 6.0002e-05 3.6 8e-05 3.6 8.0002e-05 0.4 0.0001 0.4 0.000100002 3.6 0.00012 3.6 0.000120002 0.4 0.00014 0.4 0.000140002 3.6 0.00016 3.6 0.000160002 0.4)
Xdut in_A in_B in_C out_Y vdd 0 NOR3
Xld_out_Y_0 out_Y ld_out_Y_0_Y vdd 0 INV
Xld_out_Y_1 out_Y ld_out_Y_1_Y vdd 0 INV
Xld_out_Y_2 out_Y ld_out_Y_2_Y vdd 0 INV
Xld_out_Y_3 out_Y ld_out_Y_3_Y vdd 0 INV
.tran 4e-08 0.00018
.control
run
linearize
set wr_singlescale
set wr_vecnames
wrdata NOR3.dat v(in_A) v(in_B) v(in_C) v(out_Y)
meas tran s_Y_0 FIND v(out_Y) AT=1.9e-05
meas tran l_Y_0 FIND v(ld_out_Y_0_Y) AT=1.9e-05
meas tran s_Y_1 FIND v(out_Y) AT=3.9e-05
meas tran l_Y_1 FIND v(ld_out_Y_0_Y) AT=3.9e-05
meas tran d_Y_1 TRIG AT=2e-05 TARG v(out_Y) VAL=1.5 TD=2e-05 CROSS=1
meas tran s_Y_2 FIND v(out_Y) AT=5.9e-05
meas tran l_Y_2 FIND v(ld_out_Y_0_Y) AT=5.9e-05
meas tran s_Y_3 FIND v(out_Y) AT=7.9e-05
meas tran l_Y_3 FIND v(ld_out_Y_0_Y) AT=7.9e-05
meas tran s_Y_4 FIND v(out_Y) AT=9.9e-05
meas tran l_Y_4 FIND v(ld_out_Y_0_Y) AT=9.9e-05
meas tran s_Y_5 FIND v(out_Y) AT=0.000119
meas tran l_Y_5 FIND v(ld_out_Y_0_Y) AT=0.000119
meas tran s_Y_6 FIND v(out_Y) AT=0.000139
meas tran l_Y_6 FIND v(ld_out_Y_0_Y) AT=0.000139
meas tran s_Y_7 FIND v(out_Y) AT=0.000159
meas tran l_Y_7 FIND v(ld_out_Y_0_Y) AT=0.000159
meas tran s_Y_8 FIND v(out_Y) AT=0.000179
meas tran l_Y_8 FIND v(ld_out_Y_0_Y) AT=0.000179
meas tran d_Y_8 TRIG AT=0.00016 TARG v(out_Y) VAL=1.5 TD=0.00016 CROSS=1
quit
.endc
.end
