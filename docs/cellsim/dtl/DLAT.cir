* DLAT — latch D transparente DTL (4 NAND2; 4 transistores NPN)
* família discrete_dtl, canto típico (VDD 5 V, 27 °C; modelos NPN: spice/BC548B.lib, DIODE: spice/1N4148.lib)
* gerado por pcbflow-cellsim --export; rodar: ngspice -b DLAT.cir (imprime as medidas e grava DLAT.dat)
*
* entradas no nível de pior caso: alto = 2.75 V, baixo = 0.4 V; Q leva 4 carga(s) INV.A
* saída: 1 se >= 2.5 V, 0 se <= 0.4 V
*
* vetores de teste (medida: valor esperado):
*   E ligado até 80 µs; D muda em 20, 40, 60, 100 e 120 µs
*   18 µs (transparente)  ->  s_0: Q=0
*   38 µs (transparente)  ->  s_1: Q=1
*   58 µs (transparente)  ->  s_2: Q=0
*   78 µs (transparente)  ->  s_3: Q=1
*   118 µs (travado)  ->  s_4: Q=1
*   138 µs (travado)  ->  s_5: Q=1
*
* pcbflow-cellsim: canto típico
.temp 27
.param kup=1 kb=1
.model NPN NPN(Is=7.049f Xti=3 Eg=1.11 Vaf=54.76 Bf=250 Ise=78.17f Ne=1.479 Ikf=24.96m Nkf=.5381 Xtb=1.5 Br=1.2 Isc=27.51f Nc=1.775 Ikr=3.321 Rc=.9706 Cjc=4.25p Mjc=.3147 Vjc=.5697 Fc=.5 Cje=11.5p Mje=.6715 Vje=.5 Tr=10n Tf=410.7p Itf=1.12 Xtf=26.19 Vtf=10)
.model DIODE D(IS=4.352E-9 N=1.906 BV=110 IBV=0.0001 RS=0.6458 CJO=7.048E-13 VJ=0.869 M=0.03 FC=0.5 TT=3.48E-9)
.subckt NAND2 A B Y VDD GND
R1 VDD d1 {4700*kup}
D1 d1 A DIODE
D2 d1 B DIODE
DS1 d1 m1 DIODE
DS2 m1 b1 DIODE
RB b1 GND {10000*kb}
RL VDD Y {1500*kup}
Q1 Y b1 GND NPN
.ends NAND2
.subckt DLAT D E Q VDD GND
X1 D E sb VDD GND NAND2
X2 sb E rb VDD GND NAND2
X3 sb QN Q VDD GND NAND2
X4 rb Q QN VDD GND NAND2
.ends DLAT
.subckt INV A Y VDD GND
R1 VDD d1 {4700*kup}
D1 d1 A DIODE
DS1 d1 m1 DIODE
DS2 m1 b1 DIODE
RB b1 GND {10000*kb}
RL VDD Y {1500*kup}
Q1 Y b1 GND NPN
.ends INV
VDD vdd 0 5
V_E in_E 0 PWL(0 2.75 8e-05 2.75 8.0002e-05 0.4)
V_D in_D 0 PWL(0 0.4 2e-05 0.4 2.0002e-05 2.75 4e-05 2.75 4.0002e-05 0.4 6e-05 0.4 6.0002e-05 2.75 0.0001 2.75 0.000100002 0.4 0.00012 0.4 0.000120002 2.75)
Xdut in_D in_E out_Q vdd 0 DLAT
Xld_out_Q_0 out_Q ld_out_Q_0_Y vdd 0 INV
Xld_out_Q_1 out_Q ld_out_Q_1_Y vdd 0 INV
Xld_out_Q_2 out_Q ld_out_Q_2_Y vdd 0 INV
Xld_out_Q_3 out_Q ld_out_Q_3_Y vdd 0 INV
.tran 4e-08 0.00014
.control
run
linearize
set wr_singlescale
set wr_vecnames
wrdata DLAT.dat v(in_E) v(in_D) v(out_Q)
meas tran s_0 FIND v(out_Q) AT=1.8e-05
meas tran s_1 FIND v(out_Q) AT=3.8e-05
meas tran s_2 FIND v(out_Q) AT=5.8e-05
meas tran s_3 FIND v(out_Q) AT=7.8e-05
meas tran s_4 FIND v(out_Q) AT=0.000118
meas tran s_5 FIND v(out_Q) AT=0.000138
meas tran dq_0 TRIG AT=2e-05 TARG v(out_Q) VAL=1.5 TD=2e-05 CROSS=1
meas tran dq_1 TRIG AT=4e-05 TARG v(out_Q) VAL=1.5 TD=4e-05 CROSS=1
meas tran dq_2 TRIG AT=6e-05 TARG v(out_Q) VAL=1.5 TD=6e-05 CROSS=1
quit
.endc
.end
