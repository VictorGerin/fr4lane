* AND2 — E de 2 entradas DTL (NAND2 + INV; 2 transistores NPN)
* família discrete_dtl, canto típico (VDD 5 V, 27 °C; modelos NPN: spice/BC548B.lib, DIODE: spice/1N4148.lib)
* gerado por pcbflow-cellsim --export; rodar: ngspice -b AND2.cir (imprime as medidas e grava AND2.dat)
*
* entradas no nível de pior caso: alto = 2.75 V, baixo = 0.4 V; Y leva 4 carga(s) INV.A
* saída: 1 se >= 2.5 V, 0 se <= 0.4 V
*
* vetores de teste (medida: valor esperado):
*   0-20 µs  A=0 B=0  ->  s_Y_0: Y=0
*   20-40 µs  A=0 B=1  ->  s_Y_1: Y=0
*   40-60 µs  A=1 B=0  ->  s_Y_2: Y=0
*   60-80 µs  A=1 B=1  ->  s_Y_3: Y=1
*   80-100 µs  A=0 B=0  ->  s_Y_4: Y=0
*
* pcbflow-cellsim: canto típico
.temp 27
.param kup=1 kb=1
.model NPN NPN(Is=7.049f Xti=3 Eg=1.11 Vaf=54.76 Bf=250 Ise=78.17f Ne=1.479 Ikf=24.96m Nkf=.5381 Xtb=1.5 Br=1.2 Isc=27.51f Nc=1.775 Ikr=3.321 Rc=.9706 Cjc=4.25p Mjc=.3147 Vjc=.5697 Fc=.5 Cje=11.5p Mje=.6715 Vje=.5 Tr=10n Tf=410.7p Itf=1.12 Xtf=26.19 Vtf=10)
.model DIODE D(IS=4.352E-9 N=1.906 BV=110 IBV=0.0001 RS=0.6458 CJO=7.048E-13 VJ=0.869 M=0.03 FC=0.5 TT=3.48E-9)
.subckt NAND2 A B Y VDD GND
R1 VDD d1 {4700*kup}
D1 d1 A DIODE
D2 d1 B DIODE
DS1 d1 m1 DIODE
DS2 m1 b1 DIODE
RB b1 GND {10000*kb}
RL VDD Y {1500*kup}
Q1 Y b1 GND NPN
.ends NAND2
.subckt INV A Y VDD GND
R1 VDD d1 {4700*kup}
D1 d1 A DIODE
DS1 d1 m1 DIODE
DS2 m1 b1 DIODE
RB b1 GND {10000*kb}
RL VDD Y {1500*kup}
Q1 Y b1 GND NPN
.ends INV
.subckt AND2 A B Y VDD GND
X1 A B n VDD GND NAND2
X2 n Y VDD GND INV
.ends AND2
VDD vdd 0 5
V_A in_A 0 PWL(0 0.4 4e-05 0.4 4.0002e-05 2.75 8e-05 2.75 8.0002e-05 0.4)
V_B in_B 0 PWL(0 0.4 2e-05 0.4 2.0002e-05 2.75 4e-05 2.75 4.0002e-05 0.4 6e-05 0.4 6.0002e-05 2.75 8e-05 2.75 8.0002e-05 0.4)
Xdut in_A in_B out_Y vdd 0 AND2
Xld_out_Y_0 out_Y ld_out_Y_0_Y vdd 0 INV
Xld_out_Y_1 out_Y ld_out_Y_1_Y vdd 0 INV
Xld_out_Y_2 out_Y ld_out_Y_2_Y vdd 0 INV
Xld_out_Y_3 out_Y ld_out_Y_3_Y vdd 0 INV
.tran 4e-08 0.0001
.control
run
linearize
set wr_singlescale
set wr_vecnames
wrdata AND2.dat v(in_A) v(in_B) v(out_Y)
meas tran s_Y_0 FIND v(out_Y) AT=1.9e-05
meas tran l_Y_0 FIND v(ld_out_Y_0_Y) AT=1.9e-05
meas tran s_Y_1 FIND v(out_Y) AT=3.9e-05
meas tran l_Y_1 FIND v(ld_out_Y_0_Y) AT=3.9e-05
meas tran s_Y_2 FIND v(out_Y) AT=5.9e-05
meas tran l_Y_2 FIND v(ld_out_Y_0_Y) AT=5.9e-05
meas tran s_Y_3 FIND v(out_Y) AT=7.9e-05
meas tran l_Y_3 FIND v(ld_out_Y_0_Y) AT=7.9e-05
meas tran d_Y_3 TRIG AT=6e-05 TARG v(out_Y) VAL=1.5 TD=6e-05 CROSS=1
meas tran s_Y_4 FIND v(out_Y) AT=9.9e-05
meas tran l_Y_4 FIND v(ld_out_Y_0_Y) AT=9.9e-05
meas tran d_Y_4 TRIG AT=8e-05 TARG v(out_Y) VAL=1.5 TD=8e-05 CROSS=1
quit
.endc
.end
