* tanque — circuito sintetizado pelo pcbflow (15 células: AND2, DFFR, INV, NOR2, NOR3, OR2, XNOR2; 201 componentes)
* família discrete_cdl, canto típico (VDD 5 V, 27 °C)
* gerado por pcbflow-cellsim --design tanque --export; rodar: ngspice -b tanque.cir
*
* entradas no nível de pior caso: alto = 4 V, baixo = 0.25 V; cada saída leva uma carga de referência
* saída: 1 se >= 3.25 V, 0 se <= 0.4 V
*
* vetores de teste (medida: valor esperado):
*   vetor 0 (0-20 µs): clk=0 rst_n=0 nivel_baixo=0 nivel_alto=0  ->  s_estado_0__0: estado[0]=0, s_estado_1__0: estado[1]=0, s_bomba_0: bomba=0
*   vetor 1 (20-40 µs): clk=0 rst_n=1 nivel_baixo=0 nivel_alto=0  ->  s_estado_0__1: estado[0]=0, s_estado_1__1: estado[1]=0, s_bomba_1: bomba=0
*   vetor 2 (40-60 µs): clk=1 rst_n=1 nivel_baixo=0 nivel_alto=0  ->  s_estado_0__2: estado[0]=1, s_estado_1__2: estado[1]=0, s_bomba_2: bomba=1
*   vetor 3 (60-80 µs): clk=0 rst_n=1 nivel_baixo=1 nivel_alto=0  ->  s_estado_0__3: estado[0]=1, s_estado_1__3: estado[1]=0, s_bomba_3: bomba=1
*   vetor 4 (80-100 µs): clk=1 rst_n=1 nivel_baixo=1 nivel_alto=0  ->  s_estado_0__4: estado[0]=1, s_estado_1__4: estado[1]=0, s_bomba_4: bomba=1
*   vetor 5 (100-120 µs): clk=0 rst_n=1 nivel_baixo=0 nivel_alto=1  ->  s_estado_0__5: estado[0]=1, s_estado_1__5: estado[1]=0, s_bomba_5: bomba=1
*   vetor 6 (120-140 µs): clk=1 rst_n=1 nivel_baixo=0 nivel_alto=1  ->  s_estado_0__6: estado[0]=0, s_estado_1__6: estado[1]=1, s_bomba_6: bomba=0
*   vetor 7 (140-160 µs): clk=0 rst_n=1 nivel_baixo=1 nivel_alto=1  ->  s_estado_0__7: estado[0]=0, s_estado_1__7: estado[1]=1, s_bomba_7: bomba=0
*   vetor 8 (160-180 µs): clk=1 rst_n=1 nivel_baixo=1 nivel_alto=1  ->  s_estado_0__8: estado[0]=0, s_estado_1__8: estado[1]=1, s_bomba_8: bomba=0
*   vetor 9 (180-200 µs): clk=0 rst_n=1 nivel_baixo=0 nivel_alto=0  ->  s_estado_0__9: estado[0]=0, s_estado_1__9: estado[1]=1, s_bomba_9: bomba=0
*   vetor 10 (200-220 µs): clk=1 rst_n=1 nivel_baixo=0 nivel_alto=0  ->  s_estado_0__10: estado[0]=1, s_estado_1__10: estado[1]=1, s_bomba_10: bomba=0
*   vetor 11 (220-240 µs): clk=0 rst_n=1 nivel_baixo=1 nivel_alto=0  ->  s_estado_0__11: estado[0]=1, s_estado_1__11: estado[1]=1, s_bomba_11: bomba=0
*   vetor 12 (240-260 µs): clk=1 rst_n=1 nivel_baixo=1 nivel_alto=0  ->  s_estado_0__12: estado[0]=1, s_estado_1__12: estado[1]=1, s_bomba_12: bomba=0
*   vetor 13 (260-280 µs): clk=0 rst_n=1 nivel_baixo=0 nivel_alto=1  ->  s_estado_0__13: estado[0]=1, s_estado_1__13: estado[1]=1, s_bomba_13: bomba=0
*   vetor 14 (280-300 µs): clk=1 rst_n=1 nivel_baixo=0 nivel_alto=1  ->  s_estado_0__14: estado[0]=0, s_estado_1__14: estado[1]=0, s_bomba_14: bomba=0
*   vetor 15 (300-320 µs): clk=0 rst_n=1 nivel_baixo=1 nivel_alto=1  ->  s_estado_0__15: estado[0]=0, s_estado_1__15: estado[1]=0, s_bomba_15: bomba=0
*   vetor 16 (320-340 µs): clk=1 rst_n=1 nivel_baixo=1 nivel_alto=1  ->  s_estado_0__16: estado[0]=0, s_estado_1__16: estado[1]=0, s_bomba_16: bomba=0
*
* pcbflow-cellsim: canto típico
.temp 27
.param kup=1 kb=1
.param kcore=1.0 kic=1.0
* Núcleo toroidal de ferrite CDL (Core-Diode Logic) — modelo para simulação analógica (pcbflow-cellsim)
*
* Na lógica CDL pura (sem transistores), o núcleo toroidal de ferrite atua como
* estágio magnético de limiar e amplificação: os sinais de entrada passam por
* diodos retificadores 1N4148 (que impedem o retorno de corrente entre entradas)
* e alimentam os enrolamentos de comando W1 (+N espiras), W2 (+N espiras) e
* WB (-N espiras, enrolamento de inibição/polarização).
*
* Física modelada:
*   - Resistência CC de cada enrolamento: 10 Ω (escalada por kcore);
*   - Força magnetomotriz (FMM) líquida normalizada em mA:
*       Immf = 1000 * (I(W1) + I(W2) - I(WB))
*     - Em OR2/BUF: os diodos excitam W1 (WB=0); qualquer entrada alta supera Ic.
*     - Em INV/NOR2/NOR3: W1 recebe polarização positiva constante de VDD (via RB=10 kΩ,
*       ~0,5 mA) mantendo a saída em 1 no repouso; qualquer entrada alta injeta corrente
*       via diodo no enrolamento de inibição WB (via R1=3,3 kΩ, ~1 mA), invertendo o
*       fluxo magnético líquido e levando a saída a 0.
*     - Em AND2: W1 e W2 recebem as duas entradas via diodos (~0,5 mA cada) enquanto
*       WB recebe polarização negativa de VDD (via RB=10 kΩ, ~0,5 mA) que cancela uma
*       única entrada alta; apenas a coincidência (A=1 e B=1) supera Ic em um único núcleo.
*   - Dinâmica de comutação de parede de domínio magnético (τ_sw ≈ 120 ns, modelada por
*     Rmag=120 Ω e Cmag=1 nF) e laço de histerese retangular (SWCORE com limiar coercivo
*     Ic = 0,14 mA ± 0,02 mA, escalado por kic);
*   - Saída S com regeneração magnética de baixa impedância (RON=50 Ω para Vdrv=4,3 V,
*     representando a tensão secundária retificada) e retorno a 0 V pelo resistor de carga
*     externo RL (2,2 kΩ ao GND) quando o núcleo é inibido/resetado.
*
* Pinos na convenção do pcbflow: w1, w2, wb, s, gnd.
.param kcore=1.0 kic=1.0
.subckt MCORE w1 w2 wb s gnd
Vw1  w1  w1m 0
Rw1  w1m gnd {10*kcore}
Vw2  w2  w2m 0
Rw2  w2m gnd {10*kcore}
Vwb  wb  wbm 0
Rwb  wbm gnd {10*kcore}
Bmmf mmf gnd V = 1000 * (i(Vw1) + i(Vw2) - i(Vwb)) / kic
Rmag mmf flx 120
Cmag flx gnd 1n
Vdrv vp  gnd 4.3
Sc   vp  s   flx gnd SWCORE
.model SWCORE SW(VT=0.14 VH=0.02 RON=50 ROFF=100MEG)
.ends MCORE
.model DIODE D(IS=4.352E-9 N=1.906 BV=110 IBV=0.0001 RS=0.6458 CJO=7.048E-13 VJ=0.869 M=0.03 FC=0.5 TT=3.48E-9)
.subckt AND2 A B Y VDD GND
D1 A d1 DIODE
R1 d1 w1 {6800*kb}
D2 B d2 DIODE
R2 d2 w2 {6800*kb}
RB VDD wb {10000*kup}
RL Y GND {2200*kb}
XT1 w1 w2 wb Y GND MCORE
.ends AND2
.subckt INV A Y VDD GND
RB VDD w1 {10000*kup}
D1 A d1 DIODE
R1 d1 wb {3300*kb}
RL Y GND {2200*kb}
XT1 w1 GND wb Y GND MCORE
.ends INV
.subckt NOR3 A B C Y VDD GND
RB VDD w1 {10000*kup}
D1 A d1 DIODE
D2 B d1 DIODE
D3 C d1 DIODE
R1 d1 wb {3300*kb}
RL Y GND {2200*kb}
XT1 w1 GND wb Y GND MCORE
.ends NOR3
.subckt NOR2 A B Y VDD GND
RB VDD w1 {10000*kup}
D1 A d1 DIODE
D2 B d1 DIODE
R1 d1 wb {3300*kb}
RL Y GND {2200*kb}
XT1 w1 GND wb Y GND MCORE
.ends NOR2
.subckt DFFR D C R Q VDD GND
X0 C ck VDD GND INV
X9 R rn VDD GND INV
X1 rn n4 n2 n1 VDD GND NOR3
X2 n1 ck n2 VDD GND NOR2
X3 n2 ck n4 n3 VDD GND NOR3
X4 n3 D n4 VDD GND NOR2
X5 rn n2 QN Q VDD GND NOR3
X6 Q n3 QN VDD GND NOR2
.ends DFFR
.subckt OR2 A B Y VDD GND
D1 A d1 DIODE
D2 B d1 DIODE
R1 d1 w1 {6800*kb}
RL Y GND {2200*kb}
XT1 w1 GND GND Y GND MCORE
.ends OR2
.subckt XNOR2 A B Y VDD GND
X1 A B ab VDD GND AND2
X2 A B nr VDD GND NOR2
X3 ab nr Y VDD GND OR2
.ends XNOR2
VDD vdd 0 5
V_clk n2 0 PWL(0 0.25 4e-05 0.25 4.0002e-05 4 6e-05 4 6.0002e-05 0.25 8e-05 0.25 8.0002e-05 4 0.0001 4 0.000100002 0.25 0.00012 0.25 0.000120002 4 0.00014 4 0.000140002 0.25 0.00016 0.25 0.000160002 4 0.00018 4 0.000180002 0.25 0.0002 0.25 0.000200002 4 0.00022 4 0.000220002 0.25 0.00024 0.25 0.000240002 4 0.00026 4 0.000260002 0.25 0.00028 0.25 0.000280002 4 0.0003 4 0.000300002 0.25 0.00032 0.25 0.000320002 4)
V_rst_n n3 0 PWL(0 0.25 2e-05 0.25 2.0002e-05 4)
V_nivel_baixo n4 0 PWL(0 0.25 6e-05 0.25 6.0002e-05 4 0.0001 4 0.000100002 0.25 0.00014 0.25 0.000140002 4 0.00018 4 0.000180002 0.25 0.00022 0.25 0.000220002 4 0.00026 4 0.000260002 0.25 0.0003 0.25 0.000300002 4)
V_nivel_alto n5 0 PWL(0 0.25 0.0001 0.25 0.000100002 4 0.00018 4 0.000180002 0.25 0.00026 0.25 0.000260002 4)
XU1 n6 n7 vdd 0 INV
XU2 n8 n9 vdd 0 INV
XU3 n5 n10 vdd 0 INV
XU4 n7 n8 n11 vdd 0 NOR2
XU5 n7 n8 n5 n12 vdd 0 NOR3
XU6 n6 n9 n10 n13 vdd 0 NOR3
XU7 n6 n8 n14 vdd 0 XNOR2
XU8 n4 n14 n15 vdd 0 AND2
XU9 n12 n13 n14 n16 vdd 0 NOR3
XU10 n12 n13 n15 n17 vdd 0 NOR3
XU11 n7 n17 n18 vdd 0 XNOR2
XU12 n9 n17 n19 vdd 0 NOR2
XU13 n16 n19 n20 vdd 0 OR2
XFF1 n18 n2 n3 n6 vdd 0 DFFR
XFF2 n20 n2 n3 n8 vdd 0 DFFR
Xld_estado_0_ n6 ldo_estado_0__Y vdd 0 INV
Xld_estado_1_ n8 ldo_estado_1__Y vdd 0 INV
Xld_bomba n11 ldo_bomba_Y vdd 0 INV
.tran 4e-08 0.00034
.control
run
linearize
set wr_singlescale
set wr_vecnames
wrdata tanque.dat v(n2) v(n3) v(n4) v(n5) v(n6) v(n8) v(n11)
meas tran s_estado_0__0 FIND v(n6) AT=1.9e-05
meas tran s_estado_1__0 FIND v(n8) AT=1.9e-05
meas tran s_bomba_0 FIND v(n11) AT=1.9e-05
meas tran s_estado_0__1 FIND v(n6) AT=3.9e-05
meas tran s_estado_1__1 FIND v(n8) AT=3.9e-05
meas tran s_bomba_1 FIND v(n11) AT=3.9e-05
meas tran s_estado_0__2 FIND v(n6) AT=5.9e-05
meas tran t_estado_0__2 WHEN v(n6)=1.75 CROSS=LAST FROM=4e-05 TO=6e-05
meas tran s_estado_1__2 FIND v(n8) AT=5.9e-05
meas tran s_bomba_2 FIND v(n11) AT=5.9e-05
meas tran t_bomba_2 WHEN v(n11)=1.75 CROSS=LAST FROM=4e-05 TO=6e-05
meas tran s_estado_0__3 FIND v(n6) AT=7.9e-05
meas tran s_estado_1__3 FIND v(n8) AT=7.9e-05
meas tran s_bomba_3 FIND v(n11) AT=7.9e-05
meas tran s_estado_0__4 FIND v(n6) AT=9.9e-05
meas tran s_estado_1__4 FIND v(n8) AT=9.9e-05
meas tran s_bomba_4 FIND v(n11) AT=9.9e-05
meas tran s_estado_0__5 FIND v(n6) AT=0.000119
meas tran s_estado_1__5 FIND v(n8) AT=0.000119
meas tran s_bomba_5 FIND v(n11) AT=0.000119
meas tran s_estado_0__6 FIND v(n6) AT=0.000139
meas tran t_estado_0__6 WHEN v(n6)=1.75 CROSS=LAST FROM=0.00012 TO=0.00014
meas tran s_estado_1__6 FIND v(n8) AT=0.000139
meas tran t_estado_1__6 WHEN v(n8)=1.75 CROSS=LAST FROM=0.00012 TO=0.00014
meas tran s_bomba_6 FIND v(n11) AT=0.000139
meas tran t_bomba_6 WHEN v(n11)=1.75 CROSS=LAST FROM=0.00012 TO=0.00014
meas tran s_estado_0__7 FIND v(n6) AT=0.000159
meas tran s_estado_1__7 FIND v(n8) AT=0.000159
meas tran s_bomba_7 FIND v(n11) AT=0.000159
meas tran s_estado_0__8 FIND v(n6) AT=0.000179
meas tran s_estado_1__8 FIND v(n8) AT=0.000179
meas tran s_bomba_8 FIND v(n11) AT=0.000179
meas tran s_estado_0__9 FIND v(n6) AT=0.000199
meas tran s_estado_1__9 FIND v(n8) AT=0.000199
meas tran s_bomba_9 FIND v(n11) AT=0.000199
meas tran s_estado_0__10 FIND v(n6) AT=0.000219
meas tran t_estado_0__10 WHEN v(n6)=1.75 CROSS=LAST FROM=0.0002 TO=0.00022
meas tran s_estado_1__10 FIND v(n8) AT=0.000219
meas tran s_bomba_10 FIND v(n11) AT=0.000219
meas tran s_estado_0__11 FIND v(n6) AT=0.000239
meas tran s_estado_1__11 FIND v(n8) AT=0.000239
meas tran s_bomba_11 FIND v(n11) AT=0.000239
meas tran s_estado_0__12 FIND v(n6) AT=0.000259
meas tran s_estado_1__12 FIND v(n8) AT=0.000259
meas tran s_bomba_12 FIND v(n11) AT=0.000259
meas tran s_estado_0__13 FIND v(n6) AT=0.000279
meas tran s_estado_1__13 FIND v(n8) AT=0.000279
meas tran s_bomba_13 FIND v(n11) AT=0.000279
meas tran s_estado_0__14 FIND v(n6) AT=0.000299
meas tran t_estado_0__14 WHEN v(n6)=1.75 CROSS=LAST FROM=0.00028 TO=0.0003
meas tran s_estado_1__14 FIND v(n8) AT=0.000299
meas tran t_estado_1__14 WHEN v(n8)=1.75 CROSS=LAST FROM=0.00028 TO=0.0003
meas tran s_bomba_14 FIND v(n11) AT=0.000299
meas tran s_estado_0__15 FIND v(n6) AT=0.000319
meas tran s_estado_1__15 FIND v(n8) AT=0.000319
meas tran s_bomba_15 FIND v(n11) AT=0.000319
meas tran s_estado_0__16 FIND v(n6) AT=0.000339
meas tran s_estado_1__16 FIND v(n8) AT=0.000339
meas tran s_bomba_16 FIND v(n11) AT=0.000339
quit
.endc
.end
