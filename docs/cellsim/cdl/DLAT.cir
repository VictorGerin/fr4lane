* DLAT — latch D transparente CDL (4 NOR2 + 1 INV; 5 núcleos toroidais)
* família discrete_cdl, canto típico (VDD 5 V, 27 °C; modelos CORE: spice/MAGAMP.lib, DIODE: spice/1N4148.lib)
* gerado por fr4lane-cellsim --export; rodar: ngspice -b DLAT.cir (imprime as medidas e grava DLAT.dat)
*
* entradas no nível de pior caso: alto = 4 V, baixo = 0.25 V; Q leva 4 carga(s) INV.A
* saída: 1 se >= 3.25 V, 0 se <= 0.4 V
*
* vetores de teste (medida: valor esperado):
*   E ligado até 80 µs; D muda em 20, 40, 60, 100 e 120 µs
*   18 µs (transparente)  ->  s_0: Q=0
*   38 µs (transparente)  ->  s_1: Q=1
*   58 µs (transparente)  ->  s_2: Q=0
*   78 µs (transparente)  ->  s_3: Q=1
*   118 µs (travado)  ->  s_4: Q=1
*   138 µs (travado)  ->  s_5: Q=1
*
* fr4lane-cellsim: canto típico
.temp 27
.param kup=1 kb=1
.param kcore=1.0 kic=1.0
* Núcleo toroidal de ferrite CDL (Core-Diode Logic) — modelo para simulação analógica (fr4lane-cellsim)
*
* Na lógica CDL pura (sem transistores), o núcleo toroidal de ferrite atua como
* estágio magnético de limiar e amplificação: os sinais de entrada passam por
* diodos retificadores 1N4148 (que impedem o retorno de corrente entre entradas)
* e alimentam os enrolamentos de comando W1 (+N espiras), W2 (+N espiras) e
* WB (-N espiras, enrolamento de inibição/polarização).
*
* Física modelada:
*   - Resistência CC de cada enrolamento: 10 Ω (escalada por kcore);
*   - Força magnetomotriz (FMM) líquida normalizada em mA:
*       Immf = 1000 * (I(W1) + I(W2) - I(WB))
*     - Em OR2/BUF: os diodos excitam W1 (WB=0); qualquer entrada alta supera Ic.
*     - Em INV/NOR2/NOR3: W1 recebe polarização positiva constante de VDD (via RB=10 kΩ,
*       ~0,5 mA) mantendo a saída em 1 no repouso; qualquer entrada alta injeta corrente
*       via diodo no enrolamento de inibição WB (via R1=3,3 kΩ, ~1 mA), invertendo o
*       fluxo magnético líquido e levando a saída a 0.
*     - Em AND2: W1 e W2 recebem as duas entradas via diodos (~0,5 mA cada) enquanto
*       WB recebe polarização negativa de VDD (via RB=10 kΩ, ~0,5 mA) que cancela uma
*       única entrada alta; apenas a coincidência (A=1 e B=1) supera Ic em um único núcleo.
*   - Dinâmica de comutação de parede de domínio magnético (τ_sw ≈ 120 ns, modelada por
*     Rmag=120 Ω e Cmag=1 nF) e laço de histerese retangular (SWCORE com limiar coercivo
*     Ic = 0,14 mA ± 0,02 mA, escalado por kic);
*   - Saída S com regeneração magnética de baixa impedância (RON=50 Ω para Vdrv=4,3 V,
*     representando a tensão secundária retificada) e retorno a 0 V pelo resistor de carga
*     externo RL (2,2 kΩ ao GND) quando o núcleo é inibido/resetado.
*
* Pinos na convenção do fr4lane: w1, w2, wb, s, gnd.
.param kcore=1.0 kic=1.0
.subckt MCORE w1 w2 wb s gnd
Vw1  w1  w1m 0
Rw1  w1m gnd {10*kcore}
Vw2  w2  w2m 0
Rw2  w2m gnd {10*kcore}
Vwb  wb  wbm 0
Rwb  wbm gnd {10*kcore}
Bmmf mmf gnd V = 1000 * (i(Vw1) + i(Vw2) - i(Vwb)) / kic
Rmag mmf flx 120
Cmag flx gnd 1n
Vdrv vp  gnd 4.3
Sc   vp  s   flx gnd SWCORE
.model SWCORE SW(VT=0.14 VH=0.02 RON=50 ROFF=100MEG)
.ends MCORE
.model DIODE D(IS=4.352E-9 N=1.906 BV=110 IBV=0.0001 RS=0.6458 CJO=7.048E-13 VJ=0.869 M=0.03 FC=0.5 TT=3.48E-9)
.subckt INV A Y VDD GND
RB VDD w1 {10000*kup}
D1 A d1 DIODE
R1 d1 wb {3300*kb}
RL Y GND {2200*kb}
XT1 w1 GND wb Y GND MCORE
.ends INV
.subckt NOR2 A B Y VDD GND
RB VDD w1 {10000*kup}
D1 A d1 DIODE
D2 B d1 DIODE
R1 d1 wb {3300*kb}
RL Y GND {2200*kb}
XT1 w1 GND wb Y GND MCORE
.ends NOR2
.subckt DLAT D E Q VDD GND
X0 E eb VDD GND INV
X1 D eb r VDD GND NOR2
X2 r eb s VDD GND NOR2
X3 r QN Q VDD GND NOR2
X4 s Q QN VDD GND NOR2
.ends DLAT
VDD vdd 0 5
V_E in_E 0 PWL(0 4 8e-05 4 8.0002e-05 0.25)
V_D in_D 0 PWL(0 0.25 2e-05 0.25 2.0002e-05 4 4e-05 4 4.0002e-05 0.25 6e-05 0.25 6.0002e-05 4 0.0001 4 0.000100002 0.25 0.00012 0.25 0.000120002 4)
Xdut in_D in_E out_Q vdd 0 DLAT
Xld_out_Q_0 out_Q ld_out_Q_0_Y vdd 0 INV
Xld_out_Q_1 out_Q ld_out_Q_1_Y vdd 0 INV
Xld_out_Q_2 out_Q ld_out_Q_2_Y vdd 0 INV
Xld_out_Q_3 out_Q ld_out_Q_3_Y vdd 0 INV
.tran 4e-08 0.00014
.control
run
linearize
set wr_singlescale
set wr_vecnames
wrdata DLAT.dat v(in_E) v(in_D) v(out_Q)
meas tran s_0 FIND v(out_Q) AT=1.8e-05
meas tran s_1 FIND v(out_Q) AT=3.8e-05
meas tran s_2 FIND v(out_Q) AT=5.8e-05
meas tran s_3 FIND v(out_Q) AT=7.8e-05
meas tran s_4 FIND v(out_Q) AT=0.000118
meas tran s_5 FIND v(out_Q) AT=0.000138
meas tran dq_0 TRIG AT=2e-05 TARG v(out_Q) VAL=1.75 TD=2e-05 CROSS=1
meas tran dq_1 TRIG AT=4e-05 TARG v(out_Q) VAL=1.75 TD=4e-05 CROSS=1
meas tran dq_2 TRIG AT=6e-05 TARG v(out_Q) VAL=1.75 TD=6e-05 CROSS=1
quit
.endc
.end
