* OAI21 — OR-AND-INVERT: Y = !((A|B)&C)
* família discrete_cmos, canto típico (VDD 5 V, 27 °C; modelos NMOS: {'file': 'spice/2N7002.lib', 'instance': 'L=100u W=100u'}, PMOS: {'file': 'spice/BSS84.lib', 'instance': 'L=100u W=100u'})
* gerado por fr4lane-cellsim --export; rodar: ngspice -b OAI21.cir (imprime as medidas e grava OAI21.dat)
*
* entradas no nível de pior caso: alto = 4.5 V, baixo = 0.5 V; Y leva 8 carga(s) INV.A
* saída: 1 se >= 3.5 V, 0 se <= 1.5 V
*
* vetores de teste (medida: valor esperado):
*   0-2 µs  A=0 B=0 C=0  ->  s_Y_0: Y=1
*   2-4 µs  A=0 B=0 C=1  ->  s_Y_1: Y=1
*   4-6 µs  A=0 B=1 C=0  ->  s_Y_2: Y=1
*   6-8 µs  A=0 B=1 C=1  ->  s_Y_3: Y=0
*   8-10 µs  A=1 B=0 C=0  ->  s_Y_4: Y=1
*   10-12 µs  A=1 B=0 C=1  ->  s_Y_5: Y=0
*   12-14 µs  A=1 B=1 C=0  ->  s_Y_6: Y=1
*   14-16 µs  A=1 B=1 C=1  ->  s_Y_7: Y=0
*   16-18 µs  A=0 B=0 C=0  ->  s_Y_8: Y=1
*
* fr4lane-cellsim: canto típico
.temp 27
.param kup=1 kb=1
.model NMOS NMOS(LEVEL=1 VTO=2.50 KP=32.0m GAMMA=3.10 PHI=.75 LAMBDA=39.9u RD=1.05 RS=1.05 IS=57.5f PB=0.800 MJ=0.460 CBD=98.8p CBS=119p CGSO=60.0n CGDO=50.0n CGBO=390n)
.model PMOS PMOS(LEVEL=1 VTO=-1.60 KP=4.87m GAMMA=1.98 PHI=.75 LAMBDA=1.25m RD=0.840 RS=0.840 IS=65.0f PB=0.800 MJ=0.460 CBD=46.6p CBS=55.9p CGSO=50.7n CGDO=42.2n CGBO=69.5n)
.subckt OAI21 A B C Y VDD GND
MP1 p1 A VDD VDD PMOS L=100u W=100u
MP2 Y B p1 p1 PMOS L=100u W=100u
MP3 Y C VDD VDD PMOS L=100u W=100u
MN1 n1 A GND GND NMOS L=100u W=100u
MN2 n1 B GND GND NMOS L=100u W=100u
MN3 Y C n1 n1 NMOS L=100u W=100u
.ends OAI21
.subckt INV A Y VDD GND
MP1 Y A VDD VDD PMOS L=100u W=100u
MN1 Y A GND GND NMOS L=100u W=100u
.ends INV
VDD vdd 0 5
V_A in_A 0 PWL(0 0.5 8e-06 0.5 8.002e-06 4.5 1.6e-05 4.5 1.6002e-05 0.5)
V_B in_B 0 PWL(0 0.5 4e-06 0.5 4.002e-06 4.5 8e-06 4.5 8.002e-06 0.5 1.2e-05 0.5 1.2002e-05 4.5 1.6e-05 4.5 1.6002e-05 0.5)
V_C in_C 0 PWL(0 0.5 2e-06 0.5 2.002e-06 4.5 4e-06 4.5 4.002e-06 0.5 6e-06 0.5 6.002e-06 4.5 8e-06 4.5 8.002e-06 0.5 1e-05 0.5 1.0002e-05 4.5 1.2e-05 4.5 1.2002e-05 0.5 1.4e-05 0.5 1.4002e-05 4.5 1.6e-05 4.5 1.6002e-05 0.5)
Xdut in_A in_B in_C out_Y vdd 0 OAI21
Xld_out_Y_0 out_Y ld_out_Y_0_Y vdd 0 INV
Xld_out_Y_1 out_Y ld_out_Y_1_Y vdd 0 INV
Xld_out_Y_2 out_Y ld_out_Y_2_Y vdd 0 INV
Xld_out_Y_3 out_Y ld_out_Y_3_Y vdd 0 INV
Xld_out_Y_4 out_Y ld_out_Y_4_Y vdd 0 INV
Xld_out_Y_5 out_Y ld_out_Y_5_Y vdd 0 INV
Xld_out_Y_6 out_Y ld_out_Y_6_Y vdd 0 INV
Xld_out_Y_7 out_Y ld_out_Y_7_Y vdd 0 INV
.tran 4e-09 1.8e-05
.control
run
linearize
set wr_singlescale
set wr_vecnames
wrdata OAI21.dat v(in_A) v(in_B) v(in_C) v(out_Y)
meas tran s_Y_0 FIND v(out_Y) AT=1.9e-06
meas tran l_Y_0 FIND v(ld_out_Y_0_Y) AT=1.9e-06
meas tran s_Y_1 FIND v(out_Y) AT=3.9e-06
meas tran l_Y_1 FIND v(ld_out_Y_0_Y) AT=3.9e-06
meas tran s_Y_2 FIND v(out_Y) AT=5.9e-06
meas tran l_Y_2 FIND v(ld_out_Y_0_Y) AT=5.9e-06
meas tran s_Y_3 FIND v(out_Y) AT=7.9e-06
meas tran l_Y_3 FIND v(ld_out_Y_0_Y) AT=7.9e-06
meas tran d_Y_3 TRIG AT=6e-06 TARG v(out_Y) VAL=2.5 TD=6e-06 CROSS=1
meas tran s_Y_4 FIND v(out_Y) AT=9.9e-06
meas tran l_Y_4 FIND v(ld_out_Y_0_Y) AT=9.9e-06
meas tran d_Y_4 TRIG AT=8e-06 TARG v(out_Y) VAL=2.5 TD=8e-06 CROSS=1
meas tran s_Y_5 FIND v(out_Y) AT=1.19e-05
meas tran l_Y_5 FIND v(ld_out_Y_0_Y) AT=1.19e-05
meas tran d_Y_5 TRIG AT=1e-05 TARG v(out_Y) VAL=2.5 TD=1e-05 CROSS=1
meas tran s_Y_6 FIND v(out_Y) AT=1.39e-05
meas tran l_Y_6 FIND v(ld_out_Y_0_Y) AT=1.39e-05
meas tran d_Y_6 TRIG AT=1.2e-05 TARG v(out_Y) VAL=2.5 TD=1.2e-05 CROSS=1
meas tran s_Y_7 FIND v(out_Y) AT=1.59e-05
meas tran l_Y_7 FIND v(ld_out_Y_0_Y) AT=1.59e-05
meas tran d_Y_7 TRIG AT=1.4e-05 TARG v(out_Y) VAL=2.5 TD=1.4e-05 CROSS=1
meas tran s_Y_8 FIND v(out_Y) AT=1.79e-05
meas tran l_Y_8 FIND v(ld_out_Y_0_Y) AT=1.79e-05
meas tran d_Y_8 TRIG AT=1.6e-05 TARG v(out_Y) VAL=2.5 TD=1.6e-05 CROSS=1
quit
.endc
.end
