* tanque — circuito sintetizado pelo fr4lane (21 células: DFFR, INV, NAND2, NAND3, NOR2, NOR3, OAI21; 152 componentes)
* família discrete_cmos, canto típico (VDD 5 V, 27 °C)
* gerado por fr4lane-cellsim --design tanque --export; rodar: ngspice -b tanque.cir
*
* entradas no nível de pior caso: alto = 4.5 V, baixo = 0.5 V; cada saída leva uma carga de referência
* saída: 1 se >= 3.5 V, 0 se <= 1.5 V
*
* vetores de teste (medida: valor esperado):
*   vetor 0 (0-2 µs): clk=0 rst_n=0 nivel_baixo=0 nivel_alto=0  ->  s_estado_0__0: estado[0]=0, s_estado_1__0: estado[1]=0, s_bomba_0: bomba=0
*   vetor 1 (2-4 µs): clk=0 rst_n=1 nivel_baixo=0 nivel_alto=0  ->  s_estado_0__1: estado[0]=0, s_estado_1__1: estado[1]=0, s_bomba_1: bomba=0
*   vetor 2 (4-6 µs): clk=1 rst_n=1 nivel_baixo=0 nivel_alto=0  ->  s_estado_0__2: estado[0]=1, s_estado_1__2: estado[1]=0, s_bomba_2: bomba=1
*   vetor 3 (6-8 µs): clk=0 rst_n=1 nivel_baixo=1 nivel_alto=0  ->  s_estado_0__3: estado[0]=1, s_estado_1__3: estado[1]=0, s_bomba_3: bomba=1
*   vetor 4 (8-10 µs): clk=1 rst_n=1 nivel_baixo=1 nivel_alto=0  ->  s_estado_0__4: estado[0]=1, s_estado_1__4: estado[1]=0, s_bomba_4: bomba=1
*   vetor 5 (10-12 µs): clk=0 rst_n=1 nivel_baixo=0 nivel_alto=1  ->  s_estado_0__5: estado[0]=1, s_estado_1__5: estado[1]=0, s_bomba_5: bomba=1
*   vetor 6 (12-14 µs): clk=1 rst_n=1 nivel_baixo=0 nivel_alto=1  ->  s_estado_0__6: estado[0]=0, s_estado_1__6: estado[1]=1, s_bomba_6: bomba=0
*   vetor 7 (14-16 µs): clk=0 rst_n=1 nivel_baixo=1 nivel_alto=1  ->  s_estado_0__7: estado[0]=0, s_estado_1__7: estado[1]=1, s_bomba_7: bomba=0
*   vetor 8 (16-18 µs): clk=1 rst_n=1 nivel_baixo=1 nivel_alto=1  ->  s_estado_0__8: estado[0]=0, s_estado_1__8: estado[1]=1, s_bomba_8: bomba=0
*   vetor 9 (18-20 µs): clk=0 rst_n=1 nivel_baixo=0 nivel_alto=0  ->  s_estado_0__9: estado[0]=0, s_estado_1__9: estado[1]=1, s_bomba_9: bomba=0
*   vetor 10 (20-22 µs): clk=1 rst_n=1 nivel_baixo=0 nivel_alto=0  ->  s_estado_0__10: estado[0]=1, s_estado_1__10: estado[1]=1, s_bomba_10: bomba=0
*   vetor 11 (22-24 µs): clk=0 rst_n=1 nivel_baixo=1 nivel_alto=0  ->  s_estado_0__11: estado[0]=1, s_estado_1__11: estado[1]=1, s_bomba_11: bomba=0
*   vetor 12 (24-26 µs): clk=1 rst_n=1 nivel_baixo=1 nivel_alto=0  ->  s_estado_0__12: estado[0]=1, s_estado_1__12: estado[1]=1, s_bomba_12: bomba=0
*   vetor 13 (26-28 µs): clk=0 rst_n=1 nivel_baixo=0 nivel_alto=1  ->  s_estado_0__13: estado[0]=1, s_estado_1__13: estado[1]=1, s_bomba_13: bomba=0
*   vetor 14 (28-30 µs): clk=1 rst_n=1 nivel_baixo=0 nivel_alto=1  ->  s_estado_0__14: estado[0]=0, s_estado_1__14: estado[1]=0, s_bomba_14: bomba=0
*   vetor 15 (30-32 µs): clk=0 rst_n=1 nivel_baixo=1 nivel_alto=1  ->  s_estado_0__15: estado[0]=0, s_estado_1__15: estado[1]=0, s_bomba_15: bomba=0
*   vetor 16 (32-34 µs): clk=1 rst_n=1 nivel_baixo=1 nivel_alto=1  ->  s_estado_0__16: estado[0]=0, s_estado_1__16: estado[1]=0, s_bomba_16: bomba=0
*
* fr4lane-cellsim: canto típico
.temp 27
.param kup=1 kb=1
.model NMOS NMOS(LEVEL=1 VTO=2.50 KP=32.0m GAMMA=3.10 PHI=.75 LAMBDA=39.9u RD=1.05 RS=1.05 IS=57.5f PB=0.800 MJ=0.460 CBD=98.8p CBS=119p CGSO=60.0n CGDO=50.0n CGBO=390n)
.model PMOS PMOS(LEVEL=1 VTO=-1.60 KP=4.87m GAMMA=1.98 PHI=.75 LAMBDA=1.25m RD=0.840 RS=0.840 IS=65.0f PB=0.800 MJ=0.460 CBD=46.6p CBS=55.9p CGSO=50.7n CGDO=42.2n CGBO=69.5n)
.subckt NAND2 A B Y VDD GND
MP1 Y A VDD VDD PMOS L=100u W=100u
MP2 Y B VDD VDD PMOS L=100u W=100u
MN1 Y A n1 n1 NMOS L=100u W=100u
MN2 n1 B GND GND NMOS L=100u W=100u
.ends NAND2
.subckt NAND3 A B C Y VDD GND
MP1 Y A VDD VDD PMOS L=100u W=100u
MP2 Y B VDD VDD PMOS L=100u W=100u
MP3 Y C VDD VDD PMOS L=100u W=100u
MN1 Y A n1 n1 NMOS L=100u W=100u
MN2 n1 B n2 n2 NMOS L=100u W=100u
MN3 n2 C GND GND NMOS L=100u W=100u
.ends NAND3
.subckt DFFR D C R Q VDD GND
X1 n4 n2 n1 VDD GND NAND2
X2 n1 R C n2 VDD GND NAND3
X3 n2 C n4 n3 VDD GND NAND3
X4 n3 R D n4 VDD GND NAND3
X5 n2 QN Q VDD GND NAND2
X6 Q R n3 QN VDD GND NAND3
.ends DFFR
.subckt INV A Y VDD GND
MP1 Y A VDD VDD PMOS L=100u W=100u
MN1 Y A GND GND NMOS L=100u W=100u
.ends INV
.subckt NOR2 A B Y VDD GND
MP1 p1 A VDD VDD PMOS L=100u W=100u
MP2 Y B p1 p1 PMOS L=100u W=100u
MN1 Y A GND GND NMOS L=100u W=100u
MN2 Y B GND GND NMOS L=100u W=100u
.ends NOR2
.subckt NOR3 A B C Y VDD GND
MP1 p1 A VDD VDD PMOS L=100u W=100u
MP2 p2 B p1 p1 PMOS L=100u W=100u
MP3 Y C p2 p2 PMOS L=100u W=100u
MN1 Y A GND GND NMOS L=100u W=100u
MN2 Y B GND GND NMOS L=100u W=100u
MN3 Y C GND GND NMOS L=100u W=100u
.ends NOR3
.subckt OAI21 A B C Y VDD GND
MP1 p1 A VDD VDD PMOS L=100u W=100u
MP2 Y B p1 p1 PMOS L=100u W=100u
MP3 Y C VDD VDD PMOS L=100u W=100u
MN1 n1 A GND GND NMOS L=100u W=100u
MN2 n1 B GND GND NMOS L=100u W=100u
MN3 Y C n1 n1 NMOS L=100u W=100u
.ends OAI21
VDD vdd 0 5
V_clk n2 0 PWL(0 0.5 4e-06 0.5 4.002e-06 4.5 6e-06 4.5 6.002e-06 0.5 8e-06 0.5 8.002e-06 4.5 1e-05 4.5 1.0002e-05 0.5 1.2e-05 0.5 1.2002e-05 4.5 1.4e-05 4.5 1.4002e-05 0.5 1.6e-05 0.5 1.6002e-05 4.5 1.8e-05 4.5 1.8002e-05 0.5 2e-05 0.5 2.0002e-05 4.5 2.2e-05 4.5 2.2002e-05 0.5 2.4e-05 0.5 2.4002e-05 4.5 2.6e-05 4.5 2.6002e-05 0.5 2.8e-05 0.5 2.8002e-05 4.5 3e-05 4.5 3.0002e-05 0.5 3.2e-05 0.5 3.2002e-05 4.5)
V_rst_n n3 0 PWL(0 0.5 2e-06 0.5 2.002e-06 4.5)
V_nivel_baixo n4 0 PWL(0 0.5 6e-06 0.5 6.002e-06 4.5 1e-05 4.5 1.0002e-05 0.5 1.4e-05 0.5 1.4002e-05 4.5 1.8e-05 4.5 1.8002e-05 0.5 2.2e-05 0.5 2.2002e-05 4.5 2.6e-05 4.5 2.6002e-05 0.5 3e-05 0.5 3.0002e-05 4.5)
V_nivel_alto n5 0 PWL(0 0.5 1e-05 0.5 1.0002e-05 4.5 1.8e-05 4.5 1.8002e-05 0.5 2.6e-05 0.5 2.6002e-05 4.5)
XU1 n4 n6 vdd 0 INV
XU2 n7 n8 vdd 0 INV
XU3 n9 n10 vdd 0 INV
XU4 n7 n10 n11 vdd 0 NAND2
XU5 n11 n12 vdd 0 INV
XU6 n7 n10 n13 vdd 0 NOR2
XU7 n8 n9 n14 vdd 0 NAND2
XU8 n7 n10 n5 n15 vdd 0 OAI21
XU9 n8 n9 n5 n16 vdd 0 NAND3
XU10 n5 n11 n16 n17 vdd 0 OAI21
XU11 n5 n12 n15 n18 vdd 0 OAI21
XU12 n6 n12 n13 n19 vdd 0 NOR3
XU13 n4 n11 n14 n20 vdd 0 NAND3
XU14 n12 n13 n18 n21 vdd 0 OAI21
XU15 n17 n19 n7 n22 vdd 0 OAI21
XU16 n8 n18 n20 n23 vdd 0 NAND3
XU17 n22 n23 n24 vdd 0 NAND2
XU18 n17 n19 n9 n25 vdd 0 OAI21
XU19 n21 n25 n26 vdd 0 NAND2
XFF1 n24 n2 n3 n7 vdd 0 DFFR
XFF2 n26 n2 n3 n9 vdd 0 DFFR
Xld_estado_0_ n7 ldo_estado_0__Y vdd 0 INV
Xld_estado_1_ n9 ldo_estado_1__Y vdd 0 INV
Xld_bomba n12 ldo_bomba_Y vdd 0 INV
.tran 4e-09 3.4e-05
.control
run
linearize
set wr_singlescale
set wr_vecnames
wrdata tanque.dat v(n2) v(n3) v(n4) v(n5) v(n7) v(n9) v(n12)
meas tran s_estado_0__0 FIND v(n7) AT=1.9e-06
meas tran s_estado_1__0 FIND v(n9) AT=1.9e-06
meas tran s_bomba_0 FIND v(n12) AT=1.9e-06
meas tran s_estado_0__1 FIND v(n7) AT=3.9e-06
meas tran s_estado_1__1 FIND v(n9) AT=3.9e-06
meas tran s_bomba_1 FIND v(n12) AT=3.9e-06
meas tran s_estado_0__2 FIND v(n7) AT=5.9e-06
meas tran t_estado_0__2 WHEN v(n7)=2.5 CROSS=LAST FROM=4e-06 TO=6e-06
meas tran s_estado_1__2 FIND v(n9) AT=5.9e-06
meas tran s_bomba_2 FIND v(n12) AT=5.9e-06
meas tran t_bomba_2 WHEN v(n12)=2.5 CROSS=LAST FROM=4e-06 TO=6e-06
meas tran s_estado_0__3 FIND v(n7) AT=7.9e-06
meas tran s_estado_1__3 FIND v(n9) AT=7.9e-06
meas tran s_bomba_3 FIND v(n12) AT=7.9e-06
meas tran s_estado_0__4 FIND v(n7) AT=9.9e-06
meas tran s_estado_1__4 FIND v(n9) AT=9.9e-06
meas tran s_bomba_4 FIND v(n12) AT=9.9e-06
meas tran s_estado_0__5 FIND v(n7) AT=1.19e-05
meas tran s_estado_1__5 FIND v(n9) AT=1.19e-05
meas tran s_bomba_5 FIND v(n12) AT=1.19e-05
meas tran s_estado_0__6 FIND v(n7) AT=1.39e-05
meas tran t_estado_0__6 WHEN v(n7)=2.5 CROSS=LAST FROM=1.2e-05 TO=1.4e-05
meas tran s_estado_1__6 FIND v(n9) AT=1.39e-05
meas tran t_estado_1__6 WHEN v(n9)=2.5 CROSS=LAST FROM=1.2e-05 TO=1.4e-05
meas tran s_bomba_6 FIND v(n12) AT=1.39e-05
meas tran t_bomba_6 WHEN v(n12)=2.5 CROSS=LAST FROM=1.2e-05 TO=1.4e-05
meas tran s_estado_0__7 FIND v(n7) AT=1.59e-05
meas tran s_estado_1__7 FIND v(n9) AT=1.59e-05
meas tran s_bomba_7 FIND v(n12) AT=1.59e-05
meas tran s_estado_0__8 FIND v(n7) AT=1.79e-05
meas tran s_estado_1__8 FIND v(n9) AT=1.79e-05
meas tran s_bomba_8 FIND v(n12) AT=1.79e-05
meas tran s_estado_0__9 FIND v(n7) AT=1.99e-05
meas tran s_estado_1__9 FIND v(n9) AT=1.99e-05
meas tran s_bomba_9 FIND v(n12) AT=1.99e-05
meas tran s_estado_0__10 FIND v(n7) AT=2.19e-05
meas tran t_estado_0__10 WHEN v(n7)=2.5 CROSS=LAST FROM=2e-05 TO=2.2e-05
meas tran s_estado_1__10 FIND v(n9) AT=2.19e-05
meas tran s_bomba_10 FIND v(n12) AT=2.19e-05
meas tran s_estado_0__11 FIND v(n7) AT=2.39e-05
meas tran s_estado_1__11 FIND v(n9) AT=2.39e-05
meas tran s_bomba_11 FIND v(n12) AT=2.39e-05
meas tran s_estado_0__12 FIND v(n7) AT=2.59e-05
meas tran s_estado_1__12 FIND v(n9) AT=2.59e-05
meas tran s_bomba_12 FIND v(n12) AT=2.59e-05
meas tran s_estado_0__13 FIND v(n7) AT=2.79e-05
meas tran s_estado_1__13 FIND v(n9) AT=2.79e-05
meas tran s_bomba_13 FIND v(n12) AT=2.79e-05
meas tran s_estado_0__14 FIND v(n7) AT=2.99e-05
meas tran t_estado_0__14 WHEN v(n7)=2.5 CROSS=LAST FROM=2.8e-05 TO=3e-05
meas tran s_estado_1__14 FIND v(n9) AT=2.99e-05
meas tran t_estado_1__14 WHEN v(n9)=2.5 CROSS=LAST FROM=2.8e-05 TO=3e-05
meas tran s_bomba_14 FIND v(n12) AT=2.99e-05
meas tran s_estado_0__15 FIND v(n7) AT=3.19e-05
meas tran s_estado_1__15 FIND v(n9) AT=3.19e-05
meas tran s_bomba_15 FIND v(n12) AT=3.19e-05
meas tran s_estado_0__16 FIND v(n7) AT=3.39e-05
meas tran s_estado_1__16 FIND v(n9) AT=3.39e-05
meas tran s_bomba_16 FIND v(n12) AT=3.39e-05
quit
.endc
.end
