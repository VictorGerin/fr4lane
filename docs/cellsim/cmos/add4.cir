* add4 — circuito sintetizado pelo fr4lane (36 células: AOI21, INV, NAND2, NOR2, NOR3, OAI21; 144 componentes)
* família discrete_cmos, canto típico (VDD 5 V, 27 °C)
* gerado por fr4lane-cellsim --design add4 --export; rodar: ngspice -b add4.cir
*
* entradas no nível de pior caso: alto = 4.5 V, baixo = 0.5 V; cada saída leva uma carga de referência
* saída: 1 se >= 3.5 V, 0 se <= 1.5 V
*
* vetores de teste (medida: valor esperado):
*   vetor 0 (0-2 µs): a[0]=1 a[1]=0 a[2]=0 a[3]=0 b[0]=0 b[1]=1 b[2]=1 b[3]=1 ci=0  ->  s_s_0__0: s[0]=1, s_s_1__0: s[1]=1, s_s_2__0: s[2]=1, s_s_3__0: s[3]=1, s_co_0: co=0
*   vetor 1 (2-4 µs): a[0]=1 a[1]=0 a[2]=1 a[3]=0 b[0]=1 b[1]=0 b[2]=1 b[3]=1 ci=0  ->  s_s_0__1: s[0]=0, s_s_1__1: s[1]=1, s_s_2__1: s[2]=0, s_s_3__1: s[3]=0, s_co_1: co=1
*   vetor 2 (4-6 µs): a[0]=0 a[1]=0 a[2]=0 a[3]=1 b[0]=1 b[1]=0 b[2]=1 b[3]=0 ci=1  ->  s_s_0__2: s[0]=0, s_s_1__2: s[1]=1, s_s_2__2: s[2]=1, s_s_3__2: s[3]=1, s_co_2: co=0
*   vetor 3 (6-8 µs): a[0]=1 a[1]=1 a[2]=1 a[3]=1 b[0]=1 b[1]=1 b[2]=1 b[3]=0 ci=0  ->  s_s_0__3: s[0]=0, s_s_1__3: s[1]=1, s_s_2__3: s[2]=1, s_s_3__3: s[3]=0, s_co_3: co=1
*   vetor 4 (8-10 µs): a[0]=1 a[1]=1 a[2]=1 a[3]=0 b[0]=0 b[1]=0 b[2]=1 b[3]=1 ci=1  ->  s_s_0__4: s[0]=0, s_s_1__4: s[1]=0, s_s_2__4: s[2]=1, s_s_3__4: s[3]=0, s_co_4: co=1
*   vetor 5 (10-12 µs): a[0]=0 a[1]=0 a[2]=1 a[3]=1 b[0]=1 b[1]=0 b[2]=1 b[3]=0 ci=0  ->  s_s_0__5: s[0]=1, s_s_1__5: s[1]=0, s_s_2__5: s[2]=0, s_s_3__5: s[3]=0, s_co_5: co=1
*   vetor 6 (12-14 µs): a[0]=0 a[1]=1 a[2]=0 a[3]=0 b[0]=1 b[1]=0 b[2]=1 b[3]=1 ci=1  ->  s_s_0__6: s[0]=0, s_s_1__6: s[1]=0, s_s_2__6: s[2]=0, s_s_3__6: s[3]=0, s_co_6: co=1
*   vetor 7 (14-16 µs): a[0]=0 a[1]=1 a[2]=1 a[3]=0 b[0]=1 b[1]=1 b[2]=0 b[3]=1 ci=0  ->  s_s_0__7: s[0]=1, s_s_1__7: s[1]=0, s_s_2__7: s[2]=0, s_s_3__7: s[3]=0, s_co_7: co=1
*   vetor 8 (16-18 µs): a[0]=1 a[1]=1 a[2]=1 a[3]=0 b[0]=0 b[1]=0 b[2]=1 b[3]=1 ci=0  ->  s_s_0__8: s[0]=1, s_s_1__8: s[1]=1, s_s_2__8: s[2]=0, s_s_3__8: s[3]=0, s_co_8: co=1
*   vetor 9 (18-20 µs): a[0]=1 a[1]=0 a[2]=0 a[3]=0 b[0]=1 b[1]=1 b[2]=1 b[3]=1 ci=0  ->  s_s_0__9: s[0]=0, s_s_1__9: s[1]=0, s_s_2__9: s[2]=0, s_s_3__9: s[3]=0, s_co_9: co=1
*   vetor 10 (20-22 µs): a[0]=0 a[1]=0 a[2]=1 a[3]=1 b[0]=0 b[1]=1 b[2]=0 b[3]=0 ci=1  ->  s_s_0__10: s[0]=1, s_s_1__10: s[1]=1, s_s_2__10: s[2]=1, s_s_3__10: s[3]=1, s_co_10: co=0
*   vetor 11 (22-24 µs): a[0]=1 a[1]=1 a[2]=1 a[3]=1 b[0]=1 b[1]=1 b[2]=0 b[3]=1 ci=1  ->  s_s_0__11: s[0]=1, s_s_1__11: s[1]=1, s_s_2__11: s[2]=0, s_s_3__11: s[3]=1, s_co_11: co=1
*   vetor 12 (24-26 µs): a[0]=1 a[1]=0 a[2]=1 a[3]=1 b[0]=1 b[1]=0 b[2]=1 b[3]=0 ci=0  ->  s_s_0__12: s[0]=0, s_s_1__12: s[1]=1, s_s_2__12: s[2]=0, s_s_3__12: s[3]=0, s_co_12: co=1
*   vetor 13 (26-28 µs): a[0]=0 a[1]=1 a[2]=0 a[3]=0 b[0]=1 b[1]=0 b[2]=0 b[3]=1 ci=0  ->  s_s_0__13: s[0]=1, s_s_1__13: s[1]=1, s_s_2__13: s[2]=0, s_s_3__13: s[3]=1, s_co_13: co=0
*   vetor 14 (28-30 µs): a[0]=1 a[1]=1 a[2]=0 a[3]=0 b[0]=0 b[1]=1 b[2]=1 b[3]=1 ci=0  ->  s_s_0__14: s[0]=1, s_s_1__14: s[1]=0, s_s_2__14: s[2]=0, s_s_3__14: s[3]=0, s_co_14: co=1
*   vetor 15 (30-32 µs): a[0]=1 a[1]=1 a[2]=1 a[3]=1 b[0]=1 b[1]=0 b[2]=0 b[3]=0 ci=0  ->  s_s_0__15: s[0]=0, s_s_1__15: s[1]=0, s_s_2__15: s[2]=0, s_s_3__15: s[3]=0, s_co_15: co=1
*   vetor 16 (32-34 µs): a[0]=0 a[1]=0 a[2]=0 a[3]=1 b[0]=0 b[1]=0 b[2]=0 b[3]=0 ci=0  ->  s_s_0__16: s[0]=0, s_s_1__16: s[1]=0, s_s_2__16: s[2]=0, s_s_3__16: s[3]=1, s_co_16: co=0
*   vetor 17 (34-36 µs): a[0]=0 a[1]=0 a[2]=0 a[3]=1 b[0]=1 b[1]=1 b[2]=1 b[3]=0 ci=0  ->  s_s_0__17: s[0]=1, s_s_1__17: s[1]=1, s_s_2__17: s[2]=1, s_s_3__17: s[3]=1, s_co_17: co=0
*   vetor 18 (36-38 µs): a[0]=0 a[1]=0 a[2]=1 a[3]=0 b[0]=1 b[1]=0 b[2]=0 b[3]=1 ci=1  ->  s_s_0__18: s[0]=0, s_s_1__18: s[1]=1, s_s_2__18: s[2]=1, s_s_3__18: s[3]=1, s_co_18: co=0
*   vetor 19 (38-40 µs): a[0]=1 a[1]=1 a[2]=0 a[3]=0 b[0]=0 b[1]=1 b[2]=0 b[3]=1 ci=0  ->  s_s_0__19: s[0]=1, s_s_1__19: s[1]=0, s_s_2__19: s[2]=1, s_s_3__19: s[3]=1, s_co_19: co=0
*   vetor 20 (40-42 µs): a[0]=1 a[1]=0 a[2]=1 a[3]=0 b[0]=1 b[1]=0 b[2]=0 b[3]=0 ci=1  ->  s_s_0__20: s[0]=1, s_s_1__20: s[1]=1, s_s_2__20: s[2]=1, s_s_3__20: s[3]=0, s_co_20: co=0
*   vetor 21 (42-44 µs): a[0]=1 a[1]=0 a[2]=1 a[3]=0 b[0]=1 b[1]=1 b[2]=1 b[3]=1 ci=0  ->  s_s_0__21: s[0]=0, s_s_1__21: s[1]=0, s_s_2__21: s[2]=1, s_s_3__21: s[3]=0, s_co_21: co=1
*   vetor 22 (44-46 µs): a[0]=0 a[1]=0 a[2]=0 a[3]=0 b[0]=1 b[1]=1 b[2]=0 b[3]=1 ci=1  ->  s_s_0__22: s[0]=0, s_s_1__22: s[1]=0, s_s_2__22: s[2]=1, s_s_3__22: s[3]=1, s_co_22: co=0
*   vetor 23 (46-48 µs): a[0]=1 a[1]=0 a[2]=1 a[3]=1 b[0]=0 b[1]=1 b[2]=0 b[3]=0 ci=0  ->  s_s_0__23: s[0]=1, s_s_1__23: s[1]=1, s_s_2__23: s[2]=1, s_s_3__23: s[3]=1, s_co_23: co=0
*   vetor 24 (48-50 µs): a[0]=1 a[1]=1 a[2]=1 a[3]=1 b[0]=1 b[1]=0 b[2]=1 b[3]=1 ci=1  ->  s_s_0__24: s[0]=1, s_s_1__24: s[1]=0, s_s_2__24: s[2]=1, s_s_3__24: s[3]=1, s_co_24: co=1
*   vetor 25 (50-52 µs): a[0]=0 a[1]=0 a[2]=1 a[3]=0 b[0]=0 b[1]=0 b[2]=1 b[3]=1 ci=0  ->  s_s_0__25: s[0]=0, s_s_1__25: s[1]=0, s_s_2__25: s[2]=0, s_s_3__25: s[3]=0, s_co_25: co=1
*   vetor 26 (52-54 µs): a[0]=1 a[1]=0 a[2]=1 a[3]=0 b[0]=0 b[1]=1 b[2]=0 b[3]=0 ci=0  ->  s_s_0__26: s[0]=1, s_s_1__26: s[1]=1, s_s_2__26: s[2]=1, s_s_3__26: s[3]=0, s_co_26: co=0
*   vetor 27 (54-56 µs): a[0]=1 a[1]=1 a[2]=0 a[3]=0 b[0]=1 b[1]=0 b[2]=1 b[3]=1 ci=0  ->  s_s_0__27: s[0]=0, s_s_1__27: s[1]=0, s_s_2__27: s[2]=0, s_s_3__27: s[3]=0, s_co_27: co=1
*   vetor 28 (56-58 µs): a[0]=1 a[1]=1 a[2]=1 a[3]=0 b[0]=0 b[1]=0 b[2]=0 b[3]=0 ci=0  ->  s_s_0__28: s[0]=1, s_s_1__28: s[1]=1, s_s_2__28: s[2]=1, s_s_3__28: s[3]=0, s_co_28: co=0
*   vetor 29 (58-60 µs): a[0]=1 a[1]=1 a[2]=1 a[3]=1 b[0]=1 b[1]=0 b[2]=0 b[3]=1 ci=1  ->  s_s_0__29: s[0]=1, s_s_1__29: s[1]=0, s_s_2__29: s[2]=0, s_s_3__29: s[3]=1, s_co_29: co=1
*   vetor 30 (60-62 µs): a[0]=1 a[1]=0 a[2]=1 a[3]=1 b[0]=0 b[1]=1 b[2]=1 b[3]=1 ci=0  ->  s_s_0__30: s[0]=1, s_s_1__30: s[1]=1, s_s_2__30: s[2]=0, s_s_3__30: s[3]=1, s_co_30: co=1
*   vetor 31 (62-64 µs): a[0]=0 a[1]=0 a[2]=0 a[3]=0 b[0]=0 b[1]=1 b[2]=0 b[3]=1 ci=0  ->  s_s_0__31: s[0]=0, s_s_1__31: s[1]=1, s_s_2__31: s[2]=0, s_s_3__31: s[3]=1, s_co_31: co=0
*   vetor 32 (64-66 µs): a[0]=1 a[1]=0 a[2]=0 a[3]=1 b[0]=0 b[1]=1 b[2]=1 b[3]=0 ci=1  ->  s_s_0__32: s[0]=0, s_s_1__32: s[1]=0, s_s_2__32: s[2]=0, s_s_3__32: s[3]=0, s_co_32: co=1
*   vetor 33 (66-68 µs): a[0]=0 a[1]=0 a[2]=1 a[3]=1 b[0]=0 b[1]=1 b[2]=0 b[3]=1 ci=1  ->  s_s_0__33: s[0]=1, s_s_1__33: s[1]=1, s_s_2__33: s[2]=1, s_s_3__33: s[3]=0, s_co_33: co=1
*   vetor 34 (68-70 µs): a[0]=0 a[1]=1 a[2]=0 a[3]=1 b[0]=1 b[1]=0 b[2]=0 b[3]=1 ci=0  ->  s_s_0__34: s[0]=1, s_s_1__34: s[1]=1, s_s_2__34: s[2]=0, s_s_3__34: s[3]=0, s_co_34: co=1
*   vetor 35 (70-72 µs): a[0]=1 a[1]=0 a[2]=0 a[3]=0 b[0]=1 b[1]=0 b[2]=1 b[3]=1 ci=1  ->  s_s_0__35: s[0]=1, s_s_1__35: s[1]=1, s_s_2__35: s[2]=1, s_s_3__35: s[3]=1, s_co_35: co=0
*   vetor 36 (72-74 µs): a[0]=0 a[1]=1 a[2]=0 a[3]=0 b[0]=1 b[1]=1 b[2]=1 b[3]=1 ci=1  ->  s_s_0__36: s[0]=0, s_s_1__36: s[1]=1, s_s_2__36: s[2]=0, s_s_3__36: s[3]=0, s_co_36: co=1
*   vetor 37 (74-76 µs): a[0]=1 a[1]=0 a[2]=0 a[3]=1 b[0]=0 b[1]=1 b[2]=0 b[3]=0 ci=0  ->  s_s_0__37: s[0]=1, s_s_1__37: s[1]=1, s_s_2__37: s[2]=0, s_s_3__37: s[3]=1, s_co_37: co=0
*   vetor 38 (76-78 µs): a[0]=1 a[1]=0 a[2]=1 a[3]=0 b[0]=1 b[1]=0 b[2]=0 b[3]=0 ci=0  ->  s_s_0__38: s[0]=0, s_s_1__38: s[1]=1, s_s_2__38: s[2]=1, s_s_3__38: s[3]=0, s_co_38: co=0
*   vetor 39 (78-80 µs): a[0]=0 a[1]=1 a[2]=0 a[3]=0 b[0]=1 b[1]=1 b[2]=0 b[3]=1 ci=1  ->  s_s_0__39: s[0]=0, s_s_1__39: s[1]=1, s_s_2__39: s[2]=1, s_s_3__39: s[3]=1, s_co_39: co=0
*   vetor 40 (80-82 µs): a[0]=0 a[1]=1 a[2]=0 a[3]=1 b[0]=0 b[1]=0 b[2]=1 b[3]=0 ci=0  ->  s_s_0__40: s[0]=0, s_s_1__40: s[1]=1, s_s_2__40: s[2]=1, s_s_3__40: s[3]=1, s_co_40: co=0
*   vetor 41 (82-84 µs): a[0]=0 a[1]=0 a[2]=1 a[3]=0 b[0]=0 b[1]=0 b[2]=1 b[3]=0 ci=0  ->  s_s_0__41: s[0]=0, s_s_1__41: s[1]=0, s_s_2__41: s[2]=0, s_s_3__41: s[3]=1, s_co_41: co=0
*   vetor 42 (84-86 µs): a[0]=0 a[1]=0 a[2]=1 a[3]=0 b[0]=0 b[1]=0 b[2]=0 b[3]=1 ci=0  ->  s_s_0__42: s[0]=0, s_s_1__42: s[1]=0, s_s_2__42: s[2]=1, s_s_3__42: s[3]=1, s_co_42: co=0
*   vetor 43 (86-88 µs): a[0]=0 a[1]=1 a[2]=1 a[3]=1 b[0]=1 b[1]=0 b[2]=0 b[3]=1 ci=0  ->  s_s_0__43: s[0]=1, s_s_1__43: s[1]=1, s_s_2__43: s[2]=1, s_s_3__43: s[3]=0, s_co_43: co=1
*   vetor 44 (88-90 µs): a[0]=1 a[1]=0 a[2]=1 a[3]=0 b[0]=1 b[1]=1 b[2]=0 b[3]=0 ci=0  ->  s_s_0__44: s[0]=0, s_s_1__44: s[1]=0, s_s_2__44: s[2]=0, s_s_3__44: s[3]=1, s_co_44: co=0
*   vetor 45 (90-92 µs): a[0]=1 a[1]=1 a[2]=1 a[3]=1 b[0]=0 b[1]=1 b[2]=0 b[3]=1 ci=0  ->  s_s_0__45: s[0]=1, s_s_1__45: s[1]=0, s_s_2__45: s[2]=0, s_s_3__45: s[3]=1, s_co_45: co=1
*   vetor 46 (92-94 µs): a[0]=1 a[1]=0 a[2]=0 a[3]=0 b[0]=0 b[1]=0 b[2]=0 b[3]=1 ci=1  ->  s_s_0__46: s[0]=0, s_s_1__46: s[1]=1, s_s_2__46: s[2]=0, s_s_3__46: s[3]=1, s_co_46: co=0
*   vetor 47 (94-96 µs): a[0]=1 a[1]=0 a[2]=0 a[3]=1 b[0]=0 b[1]=0 b[2]=1 b[3]=1 ci=0  ->  s_s_0__47: s[0]=1, s_s_1__47: s[1]=0, s_s_2__47: s[2]=1, s_s_3__47: s[3]=0, s_co_47: co=1
*   vetor 48 (96-98 µs): a[0]=0 a[1]=0 a[2]=0 a[3]=0 b[0]=1 b[1]=1 b[2]=1 b[3]=1 ci=0  ->  s_s_0__48: s[0]=1, s_s_1__48: s[1]=1, s_s_2__48: s[2]=1, s_s_3__48: s[3]=1, s_co_48: co=0
*   vetor 49 (98-100 µs): a[0]=0 a[1]=1 a[2]=0 a[3]=0 b[0]=0 b[1]=0 b[2]=1 b[3]=1 ci=1  ->  s_s_0__49: s[0]=1, s_s_1__49: s[1]=1, s_s_2__49: s[2]=1, s_s_3__49: s[3]=1, s_co_49: co=0
*   vetor 50 (100-102 µs): a[0]=1 a[1]=1 a[2]=0 a[3]=1 b[0]=0 b[1]=0 b[2]=0 b[3]=0 ci=1  ->  s_s_0__50: s[0]=0, s_s_1__50: s[1]=0, s_s_2__50: s[2]=1, s_s_3__50: s[3]=1, s_co_50: co=0
*   vetor 51 (102-104 µs): a[0]=1 a[1]=0 a[2]=0 a[3]=0 b[0]=1 b[1]=0 b[2]=1 b[3]=0 ci=1  ->  s_s_0__51: s[0]=1, s_s_1__51: s[1]=1, s_s_2__51: s[2]=1, s_s_3__51: s[3]=0, s_co_51: co=0
*   vetor 52 (104-106 µs): a[0]=1 a[1]=1 a[2]=0 a[3]=1 b[0]=1 b[1]=1 b[2]=1 b[3]=1 ci=0  ->  s_s_0__52: s[0]=0, s_s_1__52: s[1]=1, s_s_2__52: s[2]=0, s_s_3__52: s[3]=1, s_co_52: co=1
*   vetor 53 (106-108 µs): a[0]=0 a[1]=0 a[2]=1 a[3]=0 b[0]=0 b[1]=1 b[2]=0 b[3]=1 ci=1  ->  s_s_0__53: s[0]=1, s_s_1__53: s[1]=1, s_s_2__53: s[2]=1, s_s_3__53: s[3]=1, s_co_53: co=0
*   vetor 54 (108-110 µs): a[0]=0 a[1]=1 a[2]=1 a[3]=0 b[0]=1 b[1]=1 b[2]=0 b[3]=1 ci=1  ->  s_s_0__54: s[0]=0, s_s_1__54: s[1]=1, s_s_2__54: s[2]=0, s_s_3__54: s[3]=0, s_co_54: co=1
*   vetor 55 (110-112 µs): a[0]=0 a[1]=0 a[2]=1 a[3]=1 b[0]=1 b[1]=0 b[2]=0 b[3]=1 ci=0  ->  s_s_0__55: s[0]=1, s_s_1__55: s[1]=0, s_s_2__55: s[2]=1, s_s_3__55: s[3]=0, s_co_55: co=1
*   vetor 56 (112-114 µs): a[0]=0 a[1]=0 a[2]=1 a[3]=0 b[0]=0 b[1]=0 b[2]=1 b[3]=1 ci=1  ->  s_s_0__56: s[0]=1, s_s_1__56: s[1]=0, s_s_2__56: s[2]=0, s_s_3__56: s[3]=0, s_co_56: co=1
*   vetor 57 (114-116 µs): a[0]=1 a[1]=1 a[2]=0 a[3]=1 b[0]=1 b[1]=1 b[2]=0 b[3]=0 ci=1  ->  s_s_0__57: s[0]=1, s_s_1__57: s[1]=1, s_s_2__57: s[2]=1, s_s_3__57: s[3]=1, s_co_57: co=0
*   vetor 58 (116-118 µs): a[0]=1 a[1]=1 a[2]=1 a[3]=0 b[0]=1 b[1]=0 b[2]=0 b[3]=1 ci=0  ->  s_s_0__58: s[0]=0, s_s_1__58: s[1]=0, s_s_2__58: s[2]=0, s_s_3__58: s[3]=0, s_co_58: co=1
*   vetor 59 (118-120 µs): a[0]=0 a[1]=1 a[2]=0 a[3]=0 b[0]=1 b[1]=1 b[2]=0 b[3]=0 ci=0  ->  s_s_0__59: s[0]=1, s_s_1__59: s[1]=0, s_s_2__59: s[2]=1, s_s_3__59: s[3]=0, s_co_59: co=0
*   vetor 60 (120-122 µs): a[0]=1 a[1]=1 a[2]=0 a[3]=1 b[0]=1 b[1]=1 b[2]=0 b[3]=0 ci=0  ->  s_s_0__60: s[0]=0, s_s_1__60: s[1]=1, s_s_2__60: s[2]=1, s_s_3__60: s[3]=1, s_co_60: co=0
*   vetor 61 (122-124 µs): a[0]=1 a[1]=0 a[2]=0 a[3]=1 b[0]=1 b[1]=1 b[2]=0 b[3]=0 ci=1  ->  s_s_0__61: s[0]=1, s_s_1__61: s[1]=0, s_s_2__61: s[2]=1, s_s_3__61: s[3]=1, s_co_61: co=0
*   vetor 62 (124-126 µs): a[0]=0 a[1]=0 a[2]=1 a[3]=0 b[0]=1 b[1]=0 b[2]=1 b[3]=1 ci=0  ->  s_s_0__62: s[0]=1, s_s_1__62: s[1]=0, s_s_2__62: s[2]=0, s_s_3__62: s[3]=0, s_co_62: co=1
*   vetor 63 (126-128 µs): a[0]=0 a[1]=0 a[2]=1 a[3]=1 b[0]=1 b[1]=1 b[2]=0 b[3]=1 ci=0  ->  s_s_0__63: s[0]=1, s_s_1__63: s[1]=1, s_s_2__63: s[2]=1, s_s_3__63: s[3]=0, s_co_63: co=1
*
* fr4lane-cellsim: canto típico
.temp 27
.param kup=1 kb=1
.model NMOS NMOS(LEVEL=1 VTO=2.50 KP=32.0m GAMMA=3.10 PHI=.75 LAMBDA=39.9u RD=1.05 RS=1.05 IS=57.5f PB=0.800 MJ=0.460 CBD=98.8p CBS=119p CGSO=60.0n CGDO=50.0n CGBO=390n)
.model PMOS PMOS(LEVEL=1 VTO=-1.60 KP=4.87m GAMMA=1.98 PHI=.75 LAMBDA=1.25m RD=0.840 RS=0.840 IS=65.0f PB=0.800 MJ=0.460 CBD=46.6p CBS=55.9p CGSO=50.7n CGDO=42.2n CGBO=69.5n)
.subckt AOI21 A B C Y VDD GND
MP1 p1 A VDD VDD PMOS L=100u W=100u
MP2 p1 B VDD VDD PMOS L=100u W=100u
MP3 Y C p1 p1 PMOS L=100u W=100u
MN1 Y A n1 n1 NMOS L=100u W=100u
MN2 n1 B GND GND NMOS L=100u W=100u
MN3 Y C GND GND NMOS L=100u W=100u
.ends AOI21
.subckt INV A Y VDD GND
MP1 Y A VDD VDD PMOS L=100u W=100u
MN1 Y A GND GND NMOS L=100u W=100u
.ends INV
.subckt NAND2 A B Y VDD GND
MP1 Y A VDD VDD PMOS L=100u W=100u
MP2 Y B VDD VDD PMOS L=100u W=100u
MN1 Y A n1 n1 NMOS L=100u W=100u
MN2 n1 B GND GND NMOS L=100u W=100u
.ends NAND2
.subckt NOR2 A B Y VDD GND
MP1 p1 A VDD VDD PMOS L=100u W=100u
MP2 Y B p1 p1 PMOS L=100u W=100u
MN1 Y A GND GND NMOS L=100u W=100u
MN2 Y B GND GND NMOS L=100u W=100u
.ends NOR2
.subckt NOR3 A B C Y VDD GND
MP1 p1 A VDD VDD PMOS L=100u W=100u
MP2 p2 B p1 p1 PMOS L=100u W=100u
MP3 Y C p2 p2 PMOS L=100u W=100u
MN1 Y A GND GND NMOS L=100u W=100u
MN2 Y B GND GND NMOS L=100u W=100u
MN3 Y C GND GND NMOS L=100u W=100u
.ends NOR3
.subckt OAI21 A B C Y VDD GND
MP1 p1 A VDD VDD PMOS L=100u W=100u
MP2 Y B p1 p1 PMOS L=100u W=100u
MP3 Y C VDD VDD PMOS L=100u W=100u
MN1 n1 A GND GND NMOS L=100u W=100u
MN2 n1 B GND GND NMOS L=100u W=100u
MN3 Y C n1 n1 NMOS L=100u W=100u
.ends OAI21
VDD vdd 0 5
V_a_0_ n2 0 PWL(0 4.5 4e-06 4.5 4.002e-06 0.5 6e-06 0.5 6.002e-06 4.5 1e-05 4.5 1.0002e-05 0.5 1.6e-05 0.5 1.6002e-05 4.5 2e-05 4.5 2.0002e-05 0.5 2.2e-05 0.5 2.2002e-05 4.5 2.6e-05 4.5 2.6002e-05 0.5 2.8e-05 0.5 2.8002e-05 4.5 3.2e-05 4.5 3.2002e-05 0.5 3.8e-05 0.5 3.8002e-05 4.5 4.4e-05 4.5 4.4002e-05 0.5 4.6e-05 0.5 4.6002e-05 4.5 5e-05 4.5 5.0002e-05 0.5 5.2e-05 0.5 5.2002e-05 4.5 6.2e-05 4.5 6.2002e-05 0.5 6.4e-05 0.5 6.4002e-05 4.5 6.6e-05 4.5 6.6002e-05 0.5 7e-05 0.5 7.0002e-05 4.5 7.2e-05 4.5 7.2002e-05 0.5 7.4e-05 0.5 7.4002e-05 4.5 7.8e-05 4.5 7.8002e-05 0.5 8.8e-05 0.5 8.8002e-05 4.5 9.6e-05 4.5 9.6002e-05 0.5 0.0001 0.5 0.000100002 4.5 0.000106 4.5 0.000106002 0.5 0.000114 0.5 0.000114002 4.5 0.000118 4.5 0.000118002 0.5 0.00012 0.5 0.000120002 4.5 0.000124 4.5 0.000124002 0.5)
V_a_1_ n3 0 PWL(0 0.5 6e-06 0.5 6.002e-06 4.5 1e-05 4.5 1.0002e-05 0.5 1.2e-05 0.5 1.2002e-05 4.5 1.8e-05 4.5 1.8002e-05 0.5 2.2e-05 0.5 2.2002e-05 4.5 2.4e-05 4.5 2.4002e-05 0.5 2.6e-05 0.5 2.6002e-05 4.5 3.2e-05 4.5 3.2002e-05 0.5 3.8e-05 0.5 3.8002e-05 4.5 4e-05 4.5 4.0002e-05 0.5 4.8e-05 0.5 4.8002e-05 4.5 5e-05 4.5 5.0002e-05 0.5 5.4e-05 0.5 5.4002e-05 4.5 6e-05 4.5 6.0002e-05 0.5 6.8e-05 0.5 6.8002e-05 4.5 7e-05 4.5 7.0002e-05 0.5 7.2e-05 0.5 7.2002e-05 4.5 7.4e-05 4.5 7.4002e-05 0.5 7.8e-05 0.5 7.8002e-05 4.5 8.2e-05 4.5 8.2002e-05 0.5 8.6e-05 0.5 8.6002e-05 4.5 8.8e-05 4.5 8.8002e-05 0.5 9e-05 0.5 9.0002e-05 4.5 9.2e-05 4.5 9.2002e-05 0.5 9.8e-05 0.5 9.8002e-05 4.5 0.000102 4.5 0.000102002 0.5 0.000104 0.5 0.000104002 4.5 0.000106 4.5 0.000106002 0.5 0.000108 0.5 0.000108002 4.5 0.00011 4.5 0.000110002 0.5 0.000114 0.5 0.000114002 4.5 0.000122 4.5 0.000122002 0.5)
V_a_2_ n4 0 PWL(0 0.5 2e-06 0.5 2.002e-06 4.5 4e-06 4.5 4.002e-06 0.5 6e-06 0.5 6.002e-06 4.5 1.2e-05 4.5 1.2002e-05 0.5 1.4e-05 0.5 1.4002e-05 4.5 1.8e-05 4.5 1.8002e-05 0.5 2e-05 0.5 2.0002e-05 4.5 2.6e-05 4.5 2.6002e-05 0.5 3e-05 0.5 3.0002e-05 4.5 3.2e-05 4.5 3.2002e-05 0.5 3.6e-05 0.5 3.6002e-05 4.5 3.8e-05 4.5 3.8002e-05 0.5 4e-05 0.5 4.0002e-05 4.5 4.4e-05 4.5 4.4002e-05 0.5 4.6e-05 0.5 4.6002e-05 4.5 5.4e-05 4.5 5.4002e-05 0.5 5.6e-05 0.5 5.6002e-05 4.5 6.2e-05 4.5 6.2002e-05 0.5 6.6e-05 0.5 6.6002e-05 4.5 6.8e-05 4.5 6.8002e-05 0.5 7.6e-05 0.5 7.6002e-05 4.5 7.8e-05 4.5 7.8002e-05 0.5 8.2e-05 0.5 8.2002e-05 4.5 9.2e-05 4.5 9.2002e-05 0.5 0.000106 0.5 0.000106002 4.5 0.000114 4.5 0.000114002 0.5 0.000116 0.5 0.000116002 4.5 0.000118 4.5 0.000118002 0.5 0.000124 0.5 0.000124002 4.5)
V_a_3_ n5 0 PWL(0 0.5 4e-06 0.5 4.002e-06 4.5 8e-06 4.5 8.002e-06 0.5 1e-05 0.5 1.0002e-05 4.5 1.2e-05 4.5 1.2002e-05 0.5 2e-05 0.5 2.0002e-05 4.5 2.6e-05 4.5 2.6002e-05 0.5 3e-05 0.5 3.0002e-05 4.5 3.6e-05 4.5 3.6002e-05 0.5 4.6e-05 0.5 4.6002e-05 4.5 5e-05 4.5 5.0002e-05 0.5 5.8e-05 0.5 5.8002e-05 4.5 6.2e-05 4.5 6.2002e-05 0.5 6.4e-05 0.5 6.4002e-05 4.5 7e-05 4.5 7.0002e-05 0.5 7.4e-05 0.5 7.4002e-05 4.5 7.6e-05 4.5 7.6002e-05 0.5 8e-05 0.5 8.0002e-05 4.5 8.2e-05 4.5 8.2002e-05 0.5 8.6e-05 0.5 8.6002e-05 4.5 8.8e-05 4.5 8.8002e-05 0.5 9e-05 0.5 9.0002e-05 4.5 9.2e-05 4.5 9.2002e-05 0.5 9.4e-05 0.5 9.4002e-05 4.5 9.6e-05 4.5 9.6002e-05 0.5 0.0001 0.5 0.000100002 4.5 0.000102 4.5 0.000102002 0.5 0.000104 0.5 0.000104002 4.5 0.000106 4.5 0.000106002 0.5 0.00011 0.5 0.000110002 4.5 0.000112 4.5 0.000112002 0.5 0.000114 0.5 0.000114002 4.5 0.000116 4.5 0.000116002 0.5 0.00012 0.5 0.000120002 4.5 0.000124 4.5 0.000124002 0.5 0.000126 0.5 0.000126002 4.5)
V_b_0_ n6 0 PWL(0 0.5 2e-06 0.5 2.002e-06 4.5 8e-06 4.5 8.002e-06 0.5 1e-05 0.5 1.0002e-05 4.5 1.6e-05 4.5 1.6002e-05 0.5 1.8e-05 0.5 1.8002e-05 4.5 2e-05 4.5 2.0002e-05 0.5 2.2e-05 0.5 2.2002e-05 4.5 2.8e-05 4.5 2.8002e-05 0.5 3e-05 0.5 3.0002e-05 4.5 3.2e-05 4.5 3.2002e-05 0.5 3.4e-05 0.5 3.4002e-05 4.5 3.8e-05 4.5 3.8002e-05 0.5 4e-05 0.5 4.0002e-05 4.5 4.6e-05 4.5 4.6002e-05 0.5 4.8e-05 0.5 4.8002e-05 4.5 5e-05 4.5 5.0002e-05 0.5 5.4e-05 0.5 5.4002e-05 4.5 5.6e-05 4.5 5.6002e-05 0.5 5.8e-05 0.5 5.8002e-05 4.5 6e-05 4.5 6.0002e-05 0.5 6.8e-05 0.5 6.8002e-05 4.5 7.4e-05 4.5 7.4002e-05 0.5 7.6e-05 0.5 7.6002e-05 4.5 8e-05 4.5 8.0002e-05 0.5 8.6e-05 0.5 8.6002e-05 4.5 9e-05 4.5 9.0002e-05 0.5 9.6e-05 0.5 9.6002e-05 4.5 9.8e-05 4.5 9.8002e-05 0.5 0.000102 0.5 0.000102002 4.5 0.000106 4.5 0.000106002 0.5 0.000108 0.5 0.000108002 4.5 0.000112 4.5 0.000112002 0.5 0.000114 0.5 0.000114002 4.5)
V_b_1_ n7 0 PWL(0 4.5 2e-06 4.5 2.002e-06 0.5 6e-06 0.5 6.002e-06 4.5 8e-06 4.5 8.002e-06 0.5 1.4e-05 0.5 1.4002e-05 4.5 1.6e-05 4.5 1.6002e-05 0.5 1.8e-05 0.5 1.8002e-05 4.5 2.4e-05 4.5 2.4002e-05 0.5 2.8e-05 0.5 2.8002e-05 4.5 3e-05 4.5 3.0002e-05 0.5 3.4e-05 0.5 3.4002e-05 4.5 3.6e-05 4.5 3.6002e-05 0.5 3.8e-05 0.5 3.8002e-05 4.5 4e-05 4.5 4.0002e-05 0.5 4.2e-05 0.5 4.2002e-05 4.5 4.8e-05 4.5 4.8002e-05 0.5 5.2e-05 0.5 5.2002e-05 4.5 5.4e-05 4.5 5.4002e-05 0.5 6e-05 0.5 6.0002e-05 4.5 6.8e-05 4.5 6.8002e-05 0.5 7.2e-05 0.5 7.2002e-05 4.5 7.6e-05 4.5 7.6002e-05 0.5 7.8e-05 0.5 7.8002e-05 4.5 8e-05 4.5 8.0002e-05 0.5 8.8e-05 0.5 8.8002e-05 4.5 9.2e-05 4.5 9.2002e-05 0.5 9.6e-05 0.5 9.6002e-05 4.5 9.8e-05 4.5 9.8002e-05 0.5 0.000104 0.5 0.000104002 4.5 0.00011 4.5 0.000110002 0.5 0.000114 0.5 0.000114002 4.5 0.000116 4.5 0.000116002 0.5 0.000118 0.5 0.000118002 4.5 0.000124 4.5 0.000124002 0.5 0.000126 0.5 0.000126002 4.5)
V_b_2_ n8 0 PWL(0 4.5 1.4e-05 4.5 1.4002e-05 0.5 1.6e-05 0.5 1.6002e-05 4.5 2e-05 4.5 2.0002e-05 0.5 2.4e-05 0.5 2.4002e-05 4.5 2.6e-05 4.5 2.6002e-05 0.5 2.8e-05 0.5 2.8002e-05 4.5 3e-05 4.5 3.0002e-05 0.5 3.4e-05 0.5 3.4002e-05 4.5 3.6e-05 4.5 3.6002e-05 0.5 4.2e-05 0.5 4.2002e-05 4.5 4.4e-05 4.5 4.4002e-05 0.5 4.8e-05 0.5 4.8002e-05 4.5 5.2e-05 4.5 5.2002e-05 0.5 5.4e-05 0.5 5.4002e-05 4.5 5.6e-05 4.5 5.6002e-05 0.5 6e-05 0.5 6.0002e-05 4.5 6.2e-05 4.5 6.2002e-05 0.5 6.4e-05 0.5 6.4002e-05 4.5 6.6e-05 4.5 6.6002e-05 0.5 7e-05 0.5 7.0002e-05 4.5 7.4e-05 4.5 7.4002e-05 0.5 8e-05 0.5 8.0002e-05 4.5 8.4e-05 4.5 8.4002e-05 0.5 9.4e-05 0.5 9.4002e-05 4.5 0.0001 4.5 0.000100002 0.5 0.000102 0.5 0.000102002 4.5 0.000106 4.5 0.000106002 0.5 0.000112 0.5 0.000112002 4.5 0.000114 4.5 0.000114002 0.5 0.000124 0.5 0.000124002 4.5 0.000126 4.5 0.000126002 0.5)
V_b_3_ n9 0 PWL(0 4.5 4e-06 4.5 4.002e-06 0.5 8e-06 0.5 8.002e-06 4.5 1e-05 4.5 1.0002e-05 0.5 1.2e-05 0.5 1.2002e-05 4.5 2e-05 4.5 2.0002e-05 0.5 2.2e-05 0.5 2.2002e-05 4.5 2.4e-05 4.5 2.4002e-05 0.5 2.6e-05 0.5 2.6002e-05 4.5 3e-05 4.5 3.0002e-05 0.5 3.6e-05 0.5 3.6002e-05 4.5 4e-05 4.5 4.0002e-05 0.5 4.2e-05 0.5 4.2002e-05 4.5 4.6e-05 4.5 4.6002e-05 0.5 4.8e-05 0.5 4.8002e-05 4.5 5.2e-05 4.5 5.2002e-05 0.5 5.4e-05 0.5 5.4002e-05 4.5 5.6e-05 4.5 5.6002e-05 0.5 5.8e-05 0.5 5.8002e-05 4.5 6.4e-05 4.5 6.4002e-05 0.5 6.6e-05 0.5 6.6002e-05 4.5 7.4e-05 4.5 7.4002e-05 0.5 7.8e-05 0.5 7.8002e-05 4.5 8e-05 4.5 8.0002e-05 0.5 8.4e-05 0.5 8.4002e-05 4.5 8.8e-05 4.5 8.8002e-05 0.5 9e-05 0.5 9.0002e-05 4.5 0.0001 4.5 0.000100002 0.5 0.000104 0.5 0.000104002 4.5 0.000114 4.5 0.000114002 0.5 0.000116 0.5 0.000116002 4.5 0.000118 4.5 0.000118002 0.5 0.000124 0.5 0.000124002 4.5)
V_ci n10 0 PWL(0 0.5 4e-06 0.5 4.002e-06 4.5 6e-06 4.5 6.002e-06 0.5 8e-06 0.5 8.002e-06 4.5 1e-05 4.5 1.0002e-05 0.5 1.2e-05 0.5 1.2002e-05 4.5 1.4e-05 4.5 1.4002e-05 0.5 2e-05 0.5 2.0002e-05 4.5 2.4e-05 4.5 2.4002e-05 0.5 3.6e-05 0.5 3.6002e-05 4.5 3.8e-05 4.5 3.8002e-05 0.5 4e-05 0.5 4.0002e-05 4.5 4.2e-05 4.5 4.2002e-05 0.5 4.4e-05 0.5 4.4002e-05 4.5 4.6e-05 4.5 4.6002e-05 0.5 4.8e-05 0.5 4.8002e-05 4.5 5e-05 4.5 5.0002e-05 0.5 5.8e-05 0.5 5.8002e-05 4.5 6e-05 4.5 6.0002e-05 0.5 6.4e-05 0.5 6.4002e-05 4.5 6.8e-05 4.5 6.8002e-05 0.5 7e-05 0.5 7.0002e-05 4.5 7.4e-05 4.5 7.4002e-05 0.5 7.8e-05 0.5 7.8002e-05 4.5 8e-05 4.5 8.0002e-05 0.5 9.2e-05 0.5 9.2002e-05 4.5 9.4e-05 4.5 9.4002e-05 0.5 9.8e-05 0.5 9.8002e-05 4.5 0.000104 4.5 0.000104002 0.5 0.000106 0.5 0.000106002 4.5 0.00011 4.5 0.000110002 0.5 0.000112 0.5 0.000112002 4.5 0.000116 4.5 0.000116002 0.5 0.000122 0.5 0.000122002 4.5 0.000124 4.5 0.000124002 0.5)
XU1 n11 n12 vdd 0 INV
XU2 n13 n14 n11 n15 vdd 0 NOR3
XU3 n16 n12 n10 n17 vdd 0 AOI21
XU4 n15 n17 n18 vdd 0 NOR2
XU5 n13 n11 n16 n19 vdd 0 OAI21
XU6 n10 n13 vdd 0 INV
XU7 n2 n6 n16 vdd 0 NAND2
XU8 n16 n14 vdd 0 INV
XU9 n2 n6 n11 vdd 0 NOR2
XU10 n20 n21 vdd 0 INV
XU11 n22 n23 n20 n24 vdd 0 NOR3
XU12 n25 n21 n19 n26 vdd 0 AOI21
XU13 n24 n26 n27 vdd 0 NOR2
XU14 n22 n20 n25 n28 vdd 0 OAI21
XU15 n19 n22 vdd 0 INV
XU16 n3 n7 n25 vdd 0 NAND2
XU17 n25 n23 vdd 0 INV
XU18 n3 n7 n20 vdd 0 NOR2
XU19 n29 n30 vdd 0 INV
XU20 n31 n32 n29 n33 vdd 0 NOR3
XU21 n34 n30 n28 n35 vdd 0 AOI21
XU22 n33 n35 n36 vdd 0 NOR2
XU23 n31 n29 n34 n37 vdd 0 OAI21
XU24 n28 n31 vdd 0 INV
XU25 n4 n8 n34 vdd 0 NAND2
XU26 n34 n32 vdd 0 INV
XU27 n4 n8 n29 vdd 0 NOR2
XU28 n38 n39 vdd 0 INV
XU29 n40 n41 n38 n42 vdd 0 NOR3
XU30 n43 n39 n37 n44 vdd 0 AOI21
XU31 n42 n44 n45 vdd 0 NOR2
XU32 n40 n38 n43 n46 vdd 0 OAI21
XU33 n37 n40 vdd 0 INV
XU34 n5 n9 n43 vdd 0 NAND2
XU35 n43 n41 vdd 0 INV
XU36 n5 n9 n38 vdd 0 NOR2
Xld_s_0_ n18 ldo_s_0__Y vdd 0 INV
Xld_s_1_ n27 ldo_s_1__Y vdd 0 INV
Xld_s_2_ n36 ldo_s_2__Y vdd 0 INV
Xld_s_3_ n45 ldo_s_3__Y vdd 0 INV
Xld_co n46 ldo_co_Y vdd 0 INV
.tran 4e-09 0.000128
.control
run
linearize
set wr_singlescale
set wr_vecnames
wrdata add4.dat v(n2) v(n3) v(n4) v(n5) v(n6) v(n7) v(n8) v(n9) v(n10) v(n18) v(n27) v(n36) v(n45) v(n46)
meas tran s_s_0__0 FIND v(n18) AT=1.9e-06
meas tran s_s_1__0 FIND v(n27) AT=1.9e-06
meas tran s_s_2__0 FIND v(n36) AT=1.9e-06
meas tran s_s_3__0 FIND v(n45) AT=1.9e-06
meas tran s_co_0 FIND v(n46) AT=1.9e-06
meas tran s_s_0__1 FIND v(n18) AT=3.9e-06
meas tran t_s_0__1 WHEN v(n18)=2.5 CROSS=LAST FROM=2e-06 TO=4e-06
meas tran s_s_1__1 FIND v(n27) AT=3.9e-06
meas tran s_s_2__1 FIND v(n36) AT=3.9e-06
meas tran t_s_2__1 WHEN v(n36)=2.5 CROSS=LAST FROM=2e-06 TO=4e-06
meas tran s_s_3__1 FIND v(n45) AT=3.9e-06
meas tran t_s_3__1 WHEN v(n45)=2.5 CROSS=LAST FROM=2e-06 TO=4e-06
meas tran s_co_1 FIND v(n46) AT=3.9e-06
meas tran t_co_1 WHEN v(n46)=2.5 CROSS=LAST FROM=2e-06 TO=4e-06
meas tran s_s_0__2 FIND v(n18) AT=5.9e-06
meas tran s_s_1__2 FIND v(n27) AT=5.9e-06
meas tran s_s_2__2 FIND v(n36) AT=5.9e-06
meas tran t_s_2__2 WHEN v(n36)=2.5 CROSS=LAST FROM=4e-06 TO=6e-06
meas tran s_s_3__2 FIND v(n45) AT=5.9e-06
meas tran t_s_3__2 WHEN v(n45)=2.5 CROSS=LAST FROM=4e-06 TO=6e-06
meas tran s_co_2 FIND v(n46) AT=5.9e-06
meas tran t_co_2 WHEN v(n46)=2.5 CROSS=LAST FROM=4e-06 TO=6e-06
meas tran s_s_0__3 FIND v(n18) AT=7.9e-06
meas tran s_s_1__3 FIND v(n27) AT=7.9e-06
meas tran s_s_2__3 FIND v(n36) AT=7.9e-06
meas tran s_s_3__3 FIND v(n45) AT=7.9e-06
meas tran t_s_3__3 WHEN v(n45)=2.5 CROSS=LAST FROM=6e-06 TO=8e-06
meas tran s_co_3 FIND v(n46) AT=7.9e-06
meas tran t_co_3 WHEN v(n46)=2.5 CROSS=LAST FROM=6e-06 TO=8e-06
meas tran s_s_0__4 FIND v(n18) AT=9.9e-06
meas tran s_s_1__4 FIND v(n27) AT=9.9e-06
meas tran t_s_1__4 WHEN v(n27)=2.5 CROSS=LAST FROM=8e-06 TO=1e-05
meas tran s_s_2__4 FIND v(n36) AT=9.9e-06
meas tran s_s_3__4 FIND v(n45) AT=9.9e-06
meas tran s_co_4 FIND v(n46) AT=9.9e-06
meas tran s_s_0__5 FIND v(n18) AT=1.19e-05
meas tran t_s_0__5 WHEN v(n18)=2.5 CROSS=LAST FROM=1e-05 TO=1.2e-05
meas tran s_s_1__5 FIND v(n27) AT=1.19e-05
meas tran s_s_2__5 FIND v(n36) AT=1.19e-05
meas tran t_s_2__5 WHEN v(n36)=2.5 CROSS=LAST FROM=1e-05 TO=1.2e-05
meas tran s_s_3__5 FIND v(n45) AT=1.19e-05
meas tran s_co_5 FIND v(n46) AT=1.19e-05
meas tran s_s_0__6 FIND v(n18) AT=1.39e-05
meas tran t_s_0__6 WHEN v(n18)=2.5 CROSS=LAST FROM=1.2e-05 TO=1.4e-05
meas tran s_s_1__6 FIND v(n27) AT=1.39e-05
meas tran s_s_2__6 FIND v(n36) AT=1.39e-05
meas tran s_s_3__6 FIND v(n45) AT=1.39e-05
meas tran s_co_6 FIND v(n46) AT=1.39e-05
meas tran s_s_0__7 FIND v(n18) AT=1.59e-05
meas tran t_s_0__7 WHEN v(n18)=2.5 CROSS=LAST FROM=1.4e-05 TO=1.6e-05
meas tran s_s_1__7 FIND v(n27) AT=1.59e-05
meas tran s_s_2__7 FIND v(n36) AT=1.59e-05
meas tran s_s_3__7 FIND v(n45) AT=1.59e-05
meas tran s_co_7 FIND v(n46) AT=1.59e-05
meas tran s_s_0__8 FIND v(n18) AT=1.79e-05
meas tran s_s_1__8 FIND v(n27) AT=1.79e-05
meas tran t_s_1__8 WHEN v(n27)=2.5 CROSS=LAST FROM=1.6e-05 TO=1.8e-05
meas tran s_s_2__8 FIND v(n36) AT=1.79e-05
meas tran s_s_3__8 FIND v(n45) AT=1.79e-05
meas tran s_co_8 FIND v(n46) AT=1.79e-05
meas tran s_s_0__9 FIND v(n18) AT=1.99e-05
meas tran t_s_0__9 WHEN v(n18)=2.5 CROSS=LAST FROM=1.8e-05 TO=2e-05
meas tran s_s_1__9 FIND v(n27) AT=1.99e-05
meas tran t_s_1__9 WHEN v(n27)=2.5 CROSS=LAST FROM=1.8e-05 TO=2e-05
meas tran s_s_2__9 FIND v(n36) AT=1.99e-05
meas tran s_s_3__9 FIND v(n45) AT=1.99e-05
meas tran s_co_9 FIND v(n46) AT=1.99e-05
meas tran s_s_0__10 FIND v(n18) AT=2.19e-05
meas tran t_s_0__10 WHEN v(n18)=2.5 CROSS=LAST FROM=2e-05 TO=2.2e-05
meas tran s_s_1__10 FIND v(n27) AT=2.19e-05
meas tran t_s_1__10 WHEN v(n27)=2.5 CROSS=LAST FROM=2e-05 TO=2.2e-05
meas tran s_s_2__10 FIND v(n36) AT=2.19e-05
meas tran t_s_2__10 WHEN v(n36)=2.5 CROSS=LAST FROM=2e-05 TO=2.2e-05
meas tran s_s_3__10 FIND v(n45) AT=2.19e-05
meas tran t_s_3__10 WHEN v(n45)=2.5 CROSS=LAST FROM=2e-05 TO=2.2e-05
meas tran s_co_10 FIND v(n46) AT=2.19e-05
meas tran t_co_10 WHEN v(n46)=2.5 CROSS=LAST FROM=2e-05 TO=2.2e-05
meas tran s_s_0__11 FIND v(n18) AT=2.39e-05
meas tran s_s_1__11 FIND v(n27) AT=2.39e-05
meas tran s_s_2__11 FIND v(n36) AT=2.39e-05
meas tran t_s_2__11 WHEN v(n36)=2.5 CROSS=LAST FROM=2.2e-05 TO=2.4e-05
meas tran s_s_3__11 FIND v(n45) AT=2.39e-05
meas tran s_co_11 FIND v(n46) AT=2.39e-05
meas tran t_co_11 WHEN v(n46)=2.5 CROSS=LAST FROM=2.2e-05 TO=2.4e-05
meas tran s_s_0__12 FIND v(n18) AT=2.59e-05
meas tran t_s_0__12 WHEN v(n18)=2.5 CROSS=LAST FROM=2.4e-05 TO=2.6e-05
meas tran s_s_1__12 FIND v(n27) AT=2.59e-05
meas tran s_s_2__12 FIND v(n36) AT=2.59e-05
meas tran s_s_3__12 FIND v(n45) AT=2.59e-05
meas tran t_s_3__12 WHEN v(n45)=2.5 CROSS=LAST FROM=2.4e-05 TO=2.6e-05
meas tran s_co_12 FIND v(n46) AT=2.59e-05
meas tran s_s_0__13 FIND v(n18) AT=2.79e-05
meas tran t_s_0__13 WHEN v(n18)=2.5 CROSS=LAST FROM=2.6e-05 TO=2.8e-05
meas tran s_s_1__13 FIND v(n27) AT=2.79e-05
meas tran s_s_2__13 FIND v(n36) AT=2.79e-05
meas tran s_s_3__13 FIND v(n45) AT=2.79e-05
meas tran t_s_3__13 WHEN v(n45)=2.5 CROSS=LAST FROM=2.6e-05 TO=2.8e-05
meas tran s_co_13 FIND v(n46) AT=2.79e-05
meas tran t_co_13 WHEN v(n46)=2.5 CROSS=LAST FROM=2.6e-05 TO=2.8e-05
meas tran s_s_0__14 FIND v(n18) AT=2.99e-05
meas tran s_s_1__14 FIND v(n27) AT=2.99e-05
meas tran t_s_1__14 WHEN v(n27)=2.5 CROSS=LAST FROM=2.8e-05 TO=3e-05
meas tran s_s_2__14 FIND v(n36) AT=2.99e-05
meas tran s_s_3__14 FIND v(n45) AT=2.99e-05
meas tran t_s_3__14 WHEN v(n45)=2.5 CROSS=LAST FROM=2.8e-05 TO=3e-05
meas tran s_co_14 FIND v(n46) AT=2.99e-05
meas tran t_co_14 WHEN v(n46)=2.5 CROSS=LAST FROM=2.8e-05 TO=3e-05
meas tran s_s_0__15 FIND v(n18) AT=3.19e-05
meas tran t_s_0__15 WHEN v(n18)=2.5 CROSS=LAST FROM=3e-05 TO=3.2e-05
meas tran s_s_1__15 FIND v(n27) AT=3.19e-05
meas tran s_s_2__15 FIND v(n36) AT=3.19e-05
meas tran s_s_3__15 FIND v(n45) AT=3.19e-05
meas tran s_co_15 FIND v(n46) AT=3.19e-05
meas tran s_s_0__16 FIND v(n18) AT=3.39e-05
meas tran s_s_1__16 FIND v(n27) AT=3.39e-05
meas tran s_s_2__16 FIND v(n36) AT=3.39e-05
meas tran s_s_3__16 FIND v(n45) AT=3.39e-05
meas tran t_s_3__16 WHEN v(n45)=2.5 CROSS=LAST FROM=3.2e-05 TO=3.4e-05
meas tran s_co_16 FIND v(n46) AT=3.39e-05
meas tran t_co_16 WHEN v(n46)=2.5 CROSS=LAST FROM=3.2e-05 TO=3.4e-05
meas tran s_s_0__17 FIND v(n18) AT=3.59e-05
meas tran t_s_0__17 WHEN v(n18)=2.5 CROSS=LAST FROM=3.4e-05 TO=3.6e-05
meas tran s_s_1__17 FIND v(n27) AT=3.59e-05
meas tran t_s_1__17 WHEN v(n27)=2.5 CROSS=LAST FROM=3.4e-05 TO=3.6e-05
meas tran s_s_2__17 FIND v(n36) AT=3.59e-05
meas tran t_s_2__17 WHEN v(n36)=2.5 CROSS=LAST FROM=3.4e-05 TO=3.6e-05
meas tran s_s_3__17 FIND v(n45) AT=3.59e-05
meas tran s_co_17 FIND v(n46) AT=3.59e-05
meas tran s_s_0__18 FIND v(n18) AT=3.79e-05
meas tran t_s_0__18 WHEN v(n18)=2.5 CROSS=LAST FROM=3.6e-05 TO=3.8e-05
meas tran s_s_1__18 FIND v(n27) AT=3.79e-05
meas tran s_s_2__18 FIND v(n36) AT=3.79e-05
meas tran s_s_3__18 FIND v(n45) AT=3.79e-05
meas tran s_co_18 FIND v(n46) AT=3.79e-05
meas tran s_s_0__19 FIND v(n18) AT=3.99e-05
meas tran t_s_0__19 WHEN v(n18)=2.5 CROSS=LAST FROM=3.8e-05 TO=4e-05
meas tran s_s_1__19 FIND v(n27) AT=3.99e-05
meas tran t_s_1__19 WHEN v(n27)=2.5 CROSS=LAST FROM=3.8e-05 TO=4e-05
meas tran s_s_2__19 FIND v(n36) AT=3.99e-05
meas tran s_s_3__19 FIND v(n45) AT=3.99e-05
meas tran s_co_19 FIND v(n46) AT=3.99e-05
meas tran s_s_0__20 FIND v(n18) AT=4.19e-05
meas tran s_s_1__20 FIND v(n27) AT=4.19e-05
meas tran t_s_1__20 WHEN v(n27)=2.5 CROSS=LAST FROM=4e-05 TO=4.2e-05
meas tran s_s_2__20 FIND v(n36) AT=4.19e-05
meas tran s_s_3__20 FIND v(n45) AT=4.19e-05
meas tran t_s_3__20 WHEN v(n45)=2.5 CROSS=LAST FROM=4e-05 TO=4.2e-05
meas tran s_co_20 FIND v(n46) AT=4.19e-05
meas tran s_s_0__21 FIND v(n18) AT=4.39e-05
meas tran t_s_0__21 WHEN v(n18)=2.5 CROSS=LAST FROM=4.2e-05 TO=4.4e-05
meas tran s_s_1__21 FIND v(n27) AT=4.39e-05
meas tran t_s_1__21 WHEN v(n27)=2.5 CROSS=LAST FROM=4.2e-05 TO=4.4e-05
meas tran s_s_2__21 FIND v(n36) AT=4.39e-05
meas tran s_s_3__21 FIND v(n45) AT=4.39e-05
meas tran s_co_21 FIND v(n46) AT=4.39e-05
meas tran t_co_21 WHEN v(n46)=2.5 CROSS=LAST FROM=4.2e-05 TO=4.4e-05
meas tran s_s_0__22 FIND v(n18) AT=4.59e-05
meas tran s_s_1__22 FIND v(n27) AT=4.59e-05
meas tran s_s_2__22 FIND v(n36) AT=4.59e-05
meas tran s_s_3__22 FIND v(n45) AT=4.59e-05
meas tran t_s_3__22 WHEN v(n45)=2.5 CROSS=LAST FROM=4.4e-05 TO=4.6e-05
meas tran s_co_22 FIND v(n46) AT=4.59e-05
meas tran t_co_22 WHEN v(n46)=2.5 CROSS=LAST FROM=4.4e-05 TO=4.6e-05
meas tran s_s_0__23 FIND v(n18) AT=4.79e-05
meas tran t_s_0__23 WHEN v(n18)=2.5 CROSS=LAST FROM=4.6e-05 TO=4.8e-05
meas tran s_s_1__23 FIND v(n27) AT=4.79e-05
meas tran t_s_1__23 WHEN v(n27)=2.5 CROSS=LAST FROM=4.6e-05 TO=4.8e-05
meas tran s_s_2__23 FIND v(n36) AT=4.79e-05
meas tran s_s_3__23 FIND v(n45) AT=4.79e-05
meas tran s_co_23 FIND v(n46) AT=4.79e-05
meas tran s_s_0__24 FIND v(n18) AT=4.99e-05
meas tran s_s_1__24 FIND v(n27) AT=4.99e-05
meas tran t_s_1__24 WHEN v(n27)=2.5 CROSS=LAST FROM=4.8e-05 TO=5e-05
meas tran s_s_2__24 FIND v(n36) AT=4.99e-05
meas tran s_s_3__24 FIND v(n45) AT=4.99e-05
meas tran s_co_24 FIND v(n46) AT=4.99e-05
meas tran t_co_24 WHEN v(n46)=2.5 CROSS=LAST FROM=4.8e-05 TO=5e-05
meas tran s_s_0__25 FIND v(n18) AT=5.19e-05
meas tran t_s_0__25 WHEN v(n18)=2.5 CROSS=LAST FROM=5e-05 TO=5.2e-05
meas tran s_s_1__25 FIND v(n27) AT=5.19e-05
meas tran s_s_2__25 FIND v(n36) AT=5.19e-05
meas tran t_s_2__25 WHEN v(n36)=2.5 CROSS=LAST FROM=5e-05 TO=5.2e-05
meas tran s_s_3__25 FIND v(n45) AT=5.19e-05
meas tran t_s_3__25 WHEN v(n45)=2.5 CROSS=LAST FROM=5e-05 TO=5.2e-05
meas tran s_co_25 FIND v(n46) AT=5.19e-05
meas tran s_s_0__26 FIND v(n18) AT=5.39e-05
meas tran t_s_0__26 WHEN v(n18)=2.5 CROSS=LAST FROM=5.2e-05 TO=5.4e-05
meas tran s_s_1__26 FIND v(n27) AT=5.39e-05
meas tran t_s_1__26 WHEN v(n27)=2.5 CROSS=LAST FROM=5.2e-05 TO=5.4e-05
meas tran s_s_2__26 FIND v(n36) AT=5.39e-05
meas tran t_s_2__26 WHEN v(n36)=2.5 CROSS=LAST FROM=5.2e-05 TO=5.4e-05
meas tran s_s_3__26 FIND v(n45) AT=5.39e-05
meas tran s_co_26 FIND v(n46) AT=5.39e-05
meas tran t_co_26 WHEN v(n46)=2.5 CROSS=LAST FROM=5.2e-05 TO=5.4e-05
meas tran s_s_0__27 FIND v(n18) AT=5.59e-05
meas tran t_s_0__27 WHEN v(n18)=2.5 CROSS=LAST FROM=5.4e-05 TO=5.6e-05
meas tran s_s_1__27 FIND v(n27) AT=5.59e-05
meas tran t_s_1__27 WHEN v(n27)=2.5 CROSS=LAST FROM=5.4e-05 TO=5.6e-05
meas tran s_s_2__27 FIND v(n36) AT=5.59e-05
meas tran t_s_2__27 WHEN v(n36)=2.5 CROSS=LAST FROM=5.4e-05 TO=5.6e-05
meas tran s_s_3__27 FIND v(n45) AT=5.59e-05
meas tran s_co_27 FIND v(n46) AT=5.59e-05
meas tran t_co_27 WHEN v(n46)=2.5 CROSS=LAST FROM=5.4e-05 TO=5.6e-05
meas tran s_s_0__28 FIND v(n18) AT=5.79e-05
meas tran t_s_0__28 WHEN v(n18)=2.5 CROSS=LAST FROM=5.6e-05 TO=5.8e-05
meas tran s_s_1__28 FIND v(n27) AT=5.79e-05
meas tran t_s_1__28 WHEN v(n27)=2.5 CROSS=LAST FROM=5.6e-05 TO=5.8e-05
meas tran s_s_2__28 FIND v(n36) AT=5.79e-05
meas tran t_s_2__28 WHEN v(n36)=2.5 CROSS=LAST FROM=5.6e-05 TO=5.8e-05
meas tran s_s_3__28 FIND v(n45) AT=5.79e-05
meas tran s_co_28 FIND v(n46) AT=5.79e-05
meas tran t_co_28 WHEN v(n46)=2.5 CROSS=LAST FROM=5.6e-05 TO=5.8e-05
meas tran s_s_0__29 FIND v(n18) AT=5.99e-05
meas tran s_s_1__29 FIND v(n27) AT=5.99e-05
meas tran t_s_1__29 WHEN v(n27)=2.5 CROSS=LAST FROM=5.8e-05 TO=6e-05
meas tran s_s_2__29 FIND v(n36) AT=5.99e-05
meas tran t_s_2__29 WHEN v(n36)=2.5 CROSS=LAST FROM=5.8e-05 TO=6e-05
meas tran s_s_3__29 FIND v(n45) AT=5.99e-05
meas tran t_s_3__29 WHEN v(n45)=2.5 CROSS=LAST FROM=5.8e-05 TO=6e-05
meas tran s_co_29 FIND v(n46) AT=5.99e-05
meas tran t_co_29 WHEN v(n46)=2.5 CROSS=LAST FROM=5.8e-05 TO=6e-05
meas tran s_s_0__30 FIND v(n18) AT=6.19e-05
meas tran s_s_1__30 FIND v(n27) AT=6.19e-05
meas tran t_s_1__30 WHEN v(n27)=2.5 CROSS=LAST FROM=6e-05 TO=6.2e-05
meas tran s_s_2__30 FIND v(n36) AT=6.19e-05
meas tran s_s_3__30 FIND v(n45) AT=6.19e-05
meas tran s_co_30 FIND v(n46) AT=6.19e-05
meas tran s_s_0__31 FIND v(n18) AT=6.39e-05
meas tran t_s_0__31 WHEN v(n18)=2.5 CROSS=LAST FROM=6.2e-05 TO=6.4e-05
meas tran s_s_1__31 FIND v(n27) AT=6.39e-05
meas tran s_s_2__31 FIND v(n36) AT=6.39e-05
meas tran s_s_3__31 FIND v(n45) AT=6.39e-05
meas tran s_co_31 FIND v(n46) AT=6.39e-05
meas tran t_co_31 WHEN v(n46)=2.5 CROSS=LAST FROM=6.2e-05 TO=6.4e-05
meas tran s_s_0__32 FIND v(n18) AT=6.59e-05
meas tran s_s_1__32 FIND v(n27) AT=6.59e-05
meas tran t_s_1__32 WHEN v(n27)=2.5 CROSS=LAST FROM=6.4e-05 TO=6.6e-05
meas tran s_s_2__32 FIND v(n36) AT=6.59e-05
meas tran s_s_3__32 FIND v(n45) AT=6.59e-05
meas tran t_s_3__32 WHEN v(n45)=2.5 CROSS=LAST FROM=6.4e-05 TO=6.6e-05
meas tran s_co_32 FIND v(n46) AT=6.59e-05
meas tran t_co_32 WHEN v(n46)=2.5 CROSS=LAST FROM=6.4e-05 TO=6.6e-05
meas tran s_s_0__33 FIND v(n18) AT=6.79e-05
meas tran t_s_0__33 WHEN v(n18)=2.5 CROSS=LAST FROM=6.6e-05 TO=6.8e-05
meas tran s_s_1__33 FIND v(n27) AT=6.79e-05
meas tran t_s_1__33 WHEN v(n27)=2.5 CROSS=LAST FROM=6.6e-05 TO=6.8e-05
meas tran s_s_2__33 FIND v(n36) AT=6.79e-05
meas tran t_s_2__33 WHEN v(n36)=2.5 CROSS=LAST FROM=6.6e-05 TO=6.8e-05
meas tran s_s_3__33 FIND v(n45) AT=6.79e-05
meas tran s_co_33 FIND v(n46) AT=6.79e-05
meas tran s_s_0__34 FIND v(n18) AT=6.99e-05
meas tran s_s_1__34 FIND v(n27) AT=6.99e-05
meas tran s_s_2__34 FIND v(n36) AT=6.99e-05
meas tran t_s_2__34 WHEN v(n36)=2.5 CROSS=LAST FROM=6.8e-05 TO=7e-05
meas tran s_s_3__34 FIND v(n45) AT=6.99e-05
meas tran s_co_34 FIND v(n46) AT=6.99e-05
meas tran s_s_0__35 FIND v(n18) AT=7.19e-05
meas tran s_s_1__35 FIND v(n27) AT=7.19e-05
meas tran s_s_2__35 FIND v(n36) AT=7.19e-05
meas tran t_s_2__35 WHEN v(n36)=2.5 CROSS=LAST FROM=7e-05 TO=7.2e-05
meas tran s_s_3__35 FIND v(n45) AT=7.19e-05
meas tran t_s_3__35 WHEN v(n45)=2.5 CROSS=LAST FROM=7e-05 TO=7.2e-05
meas tran s_co_35 FIND v(n46) AT=7.19e-05
meas tran t_co_35 WHEN v(n46)=2.5 CROSS=LAST FROM=7e-05 TO=7.2e-05
meas tran s_s_0__36 FIND v(n18) AT=7.39e-05
meas tran t_s_0__36 WHEN v(n18)=2.5 CROSS=LAST FROM=7.2e-05 TO=7.4e-05
meas tran s_s_1__36 FIND v(n27) AT=7.39e-05
meas tran s_s_2__36 FIND v(n36) AT=7.39e-05
meas tran t_s_2__36 WHEN v(n36)=2.5 CROSS=LAST FROM=7.2e-05 TO=7.4e-05
meas tran s_s_3__36 FIND v(n45) AT=7.39e-05
meas tran t_s_3__36 WHEN v(n45)=2.5 CROSS=LAST FROM=7.2e-05 TO=7.4e-05
meas tran s_co_36 FIND v(n46) AT=7.39e-05
meas tran t_co_36 WHEN v(n46)=2.5 CROSS=LAST FROM=7.2e-05 TO=7.4e-05
meas tran s_s_0__37 FIND v(n18) AT=7.59e-05
meas tran t_s_0__37 WHEN v(n18)=2.5 CROSS=LAST FROM=7.4e-05 TO=7.6e-05
meas tran s_s_1__37 FIND v(n27) AT=7.59e-05
meas tran s_s_2__37 FIND v(n36) AT=7.59e-05
meas tran s_s_3__37 FIND v(n45) AT=7.59e-05
meas tran t_s_3__37 WHEN v(n45)=2.5 CROSS=LAST FROM=7.4e-05 TO=7.6e-05
meas tran s_co_37 FIND v(n46) AT=7.59e-05
meas tran t_co_37 WHEN v(n46)=2.5 CROSS=LAST FROM=7.4e-05 TO=7.6e-05
meas tran s_s_0__38 FIND v(n18) AT=7.79e-05
meas tran t_s_0__38 WHEN v(n18)=2.5 CROSS=LAST FROM=7.6e-05 TO=7.8e-05
meas tran s_s_1__38 FIND v(n27) AT=7.79e-05
meas tran s_s_2__38 FIND v(n36) AT=7.79e-05
meas tran t_s_2__38 WHEN v(n36)=2.5 CROSS=LAST FROM=7.6e-05 TO=7.8e-05
meas tran s_s_3__38 FIND v(n45) AT=7.79e-05
meas tran t_s_3__38 WHEN v(n45)=2.5 CROSS=LAST FROM=7.6e-05 TO=7.8e-05
meas tran s_co_38 FIND v(n46) AT=7.79e-05
meas tran s_s_0__39 FIND v(n18) AT=7.99e-05
meas tran s_s_1__39 FIND v(n27) AT=7.99e-05
meas tran s_s_2__39 FIND v(n36) AT=7.99e-05
meas tran s_s_3__39 FIND v(n45) AT=7.99e-05
meas tran t_s_3__39 WHEN v(n45)=2.5 CROSS=LAST FROM=7.8e-05 TO=8e-05
meas tran s_co_39 FIND v(n46) AT=7.99e-05
meas tran s_s_0__40 FIND v(n18) AT=8.19e-05
meas tran s_s_1__40 FIND v(n27) AT=8.19e-05
meas tran s_s_2__40 FIND v(n36) AT=8.19e-05
meas tran s_s_3__40 FIND v(n45) AT=8.19e-05
meas tran s_co_40 FIND v(n46) AT=8.19e-05
meas tran s_s_0__41 FIND v(n18) AT=8.39e-05
meas tran s_s_1__41 FIND v(n27) AT=8.39e-05
meas tran t_s_1__41 WHEN v(n27)=2.5 CROSS=LAST FROM=8.2e-05 TO=8.4e-05
meas tran s_s_2__41 FIND v(n36) AT=8.39e-05
meas tran t_s_2__41 WHEN v(n36)=2.5 CROSS=LAST FROM=8.2e-05 TO=8.4e-05
meas tran s_s_3__41 FIND v(n45) AT=8.39e-05
meas tran s_co_41 FIND v(n46) AT=8.39e-05
meas tran s_s_0__42 FIND v(n18) AT=8.59e-05
meas tran s_s_1__42 FIND v(n27) AT=8.59e-05
meas tran s_s_2__42 FIND v(n36) AT=8.59e-05
meas tran t_s_2__42 WHEN v(n36)=2.5 CROSS=LAST FROM=8.4e-05 TO=8.6e-05
meas tran s_s_3__42 FIND v(n45) AT=8.59e-05
meas tran s_co_42 FIND v(n46) AT=8.59e-05
meas tran s_s_0__43 FIND v(n18) AT=8.79e-05
meas tran t_s_0__43 WHEN v(n18)=2.5 CROSS=LAST FROM=8.6e-05 TO=8.8e-05
meas tran s_s_1__43 FIND v(n27) AT=8.79e-05
meas tran t_s_1__43 WHEN v(n27)=2.5 CROSS=LAST FROM=8.6e-05 TO=8.8e-05
meas tran s_s_2__43 FIND v(n36) AT=8.79e-05
meas tran s_s_3__43 FIND v(n45) AT=8.79e-05
meas tran t_s_3__43 WHEN v(n45)=2.5 CROSS=LAST FROM=8.6e-05 TO=8.8e-05
meas tran s_co_43 FIND v(n46) AT=8.79e-05
meas tran t_co_43 WHEN v(n46)=2.5 CROSS=LAST FROM=8.6e-05 TO=8.8e-05
meas tran s_s_0__44 FIND v(n18) AT=8.99e-05
meas tran t_s_0__44 WHEN v(n18)=2.5 CROSS=LAST FROM=8.8e-05 TO=9e-05
meas tran s_s_1__44 FIND v(n27) AT=8.99e-05
meas tran t_s_1__44 WHEN v(n27)=2.5 CROSS=LAST FROM=8.8e-05 TO=9e-05
meas tran s_s_2__44 FIND v(n36) AT=8.99e-05
meas tran t_s_2__44 WHEN v(n36)=2.5 CROSS=LAST FROM=8.8e-05 TO=9e-05
meas tran s_s_3__44 FIND v(n45) AT=8.99e-05
meas tran t_s_3__44 WHEN v(n45)=2.5 CROSS=LAST FROM=8.8e-05 TO=9e-05
meas tran s_co_44 FIND v(n46) AT=8.99e-05
meas tran t_co_44 WHEN v(n46)=2.5 CROSS=LAST FROM=8.8e-05 TO=9e-05
meas tran s_s_0__45 FIND v(n18) AT=9.19e-05
meas tran t_s_0__45 WHEN v(n18)=2.5 CROSS=LAST FROM=9e-05 TO=9.2e-05
meas tran s_s_1__45 FIND v(n27) AT=9.19e-05
meas tran s_s_2__45 FIND v(n36) AT=9.19e-05
meas tran s_s_3__45 FIND v(n45) AT=9.19e-05
meas tran s_co_45 FIND v(n46) AT=9.19e-05
meas tran t_co_45 WHEN v(n46)=2.5 CROSS=LAST FROM=9e-05 TO=9.2e-05
meas tran s_s_0__46 FIND v(n18) AT=9.39e-05
meas tran t_s_0__46 WHEN v(n18)=2.5 CROSS=LAST FROM=9.2e-05 TO=9.4e-05
meas tran s_s_1__46 FIND v(n27) AT=9.39e-05
meas tran t_s_1__46 WHEN v(n27)=2.5 CROSS=LAST FROM=9.2e-05 TO=9.4e-05
meas tran s_s_2__46 FIND v(n36) AT=9.39e-05
meas tran s_s_3__46 FIND v(n45) AT=9.39e-05
meas tran s_co_46 FIND v(n46) AT=9.39e-05
meas tran t_co_46 WHEN v(n46)=2.5 CROSS=LAST FROM=9.2e-05 TO=9.4e-05
meas tran s_s_0__47 FIND v(n18) AT=9.59e-05
meas tran t_s_0__47 WHEN v(n18)=2.5 CROSS=LAST FROM=9.4e-05 TO=9.6e-05
meas tran s_s_1__47 FIND v(n27) AT=9.59e-05
meas tran t_s_1__47 WHEN v(n27)=2.5 CROSS=LAST FROM=9.4e-05 TO=9.6e-05
meas tran s_s_2__47 FIND v(n36) AT=9.59e-05
meas tran t_s_2__47 WHEN v(n36)=2.5 CROSS=LAST FROM=9.4e-05 TO=9.6e-05
meas tran s_s_3__47 FIND v(n45) AT=9.59e-05
meas tran t_s_3__47 WHEN v(n45)=2.5 CROSS=LAST FROM=9.4e-05 TO=9.6e-05
meas tran s_co_47 FIND v(n46) AT=9.59e-05
meas tran t_co_47 WHEN v(n46)=2.5 CROSS=LAST FROM=9.4e-05 TO=9.6e-05
meas tran s_s_0__48 FIND v(n18) AT=9.79e-05
meas tran s_s_1__48 FIND v(n27) AT=9.79e-05
meas tran t_s_1__48 WHEN v(n27)=2.5 CROSS=LAST FROM=9.6e-05 TO=9.8e-05
meas tran s_s_2__48 FIND v(n36) AT=9.79e-05
meas tran s_s_3__48 FIND v(n45) AT=9.79e-05
meas tran t_s_3__48 WHEN v(n45)=2.5 CROSS=LAST FROM=9.6e-05 TO=9.8e-05
meas tran s_co_48 FIND v(n46) AT=9.79e-05
meas tran t_co_48 WHEN v(n46)=2.5 CROSS=LAST FROM=9.6e-05 TO=9.8e-05
meas tran s_s_0__49 FIND v(n18) AT=9.99e-05
meas tran s_s_1__49 FIND v(n27) AT=9.99e-05
meas tran s_s_2__49 FIND v(n36) AT=9.99e-05
meas tran s_s_3__49 FIND v(n45) AT=9.99e-05
meas tran s_co_49 FIND v(n46) AT=9.99e-05
meas tran s_s_0__50 FIND v(n18) AT=0.0001019
meas tran t_s_0__50 WHEN v(n18)=2.5 CROSS=LAST FROM=0.0001 TO=0.000102
meas tran s_s_1__50 FIND v(n27) AT=0.0001019
meas tran t_s_1__50 WHEN v(n27)=2.5 CROSS=LAST FROM=0.0001 TO=0.000102
meas tran s_s_2__50 FIND v(n36) AT=0.0001019
meas tran s_s_3__50 FIND v(n45) AT=0.0001019
meas tran s_co_50 FIND v(n46) AT=0.0001019
meas tran s_s_0__51 FIND v(n18) AT=0.0001039
meas tran t_s_0__51 WHEN v(n18)=2.5 CROSS=LAST FROM=0.000102 TO=0.000104
meas tran s_s_1__51 FIND v(n27) AT=0.0001039
meas tran t_s_1__51 WHEN v(n27)=2.5 CROSS=LAST FROM=0.000102 TO=0.000104
meas tran s_s_2__51 FIND v(n36) AT=0.0001039
meas tran s_s_3__51 FIND v(n45) AT=0.0001039
meas tran t_s_3__51 WHEN v(n45)=2.5 CROSS=LAST FROM=0.000102 TO=0.000104
meas tran s_co_51 FIND v(n46) AT=0.0001039
meas tran s_s_0__52 FIND v(n18) AT=0.0001059
meas tran t_s_0__52 WHEN v(n18)=2.5 CROSS=LAST FROM=0.000104 TO=0.000106
meas tran s_s_1__52 FIND v(n27) AT=0.0001059
meas tran s_s_2__52 FIND v(n36) AT=0.0001059
meas tran t_s_2__52 WHEN v(n36)=2.5 CROSS=LAST FROM=0.000104 TO=0.000106
meas tran s_s_3__52 FIND v(n45) AT=0.0001059
meas tran t_s_3__52 WHEN v(n45)=2.5 CROSS=LAST FROM=0.000104 TO=0.000106
meas tran s_co_52 FIND v(n46) AT=0.0001059
meas tran t_co_52 WHEN v(n46)=2.5 CROSS=LAST FROM=0.000104 TO=0.000106
meas tran s_s_0__53 FIND v(n18) AT=0.0001079
meas tran t_s_0__53 WHEN v(n18)=2.5 CROSS=LAST FROM=0.000106 TO=0.000108
meas tran s_s_1__53 FIND v(n27) AT=0.0001079
meas tran s_s_2__53 FIND v(n36) AT=0.0001079
meas tran t_s_2__53 WHEN v(n36)=2.5 CROSS=LAST FROM=0.000106 TO=0.000108
meas tran s_s_3__53 FIND v(n45) AT=0.0001079
meas tran s_co_53 FIND v(n46) AT=0.0001079
meas tran t_co_53 WHEN v(n46)=2.5 CROSS=LAST FROM=0.000106 TO=0.000108
meas tran s_s_0__54 FIND v(n18) AT=0.0001099
meas tran t_s_0__54 WHEN v(n18)=2.5 CROSS=LAST FROM=0.000108 TO=0.00011
meas tran s_s_1__54 FIND v(n27) AT=0.0001099
meas tran s_s_2__54 FIND v(n36) AT=0.0001099
meas tran t_s_2__54 WHEN v(n36)=2.5 CROSS=LAST FROM=0.000108 TO=0.00011
meas tran s_s_3__54 FIND v(n45) AT=0.0001099
meas tran t_s_3__54 WHEN v(n45)=2.5 CROSS=LAST FROM=0.000108 TO=0.00011
meas tran s_co_54 FIND v(n46) AT=0.0001099
meas tran t_co_54 WHEN v(n46)=2.5 CROSS=LAST FROM=0.000108 TO=0.00011
meas tran s_s_0__55 FIND v(n18) AT=0.0001119
meas tran t_s_0__55 WHEN v(n18)=2.5 CROSS=LAST FROM=0.00011 TO=0.000112
meas tran s_s_1__55 FIND v(n27) AT=0.0001119
meas tran t_s_1__55 WHEN v(n27)=2.5 CROSS=LAST FROM=0.00011 TO=0.000112
meas tran s_s_2__55 FIND v(n36) AT=0.0001119
meas tran t_s_2__55 WHEN v(n36)=2.5 CROSS=LAST FROM=0.00011 TO=0.000112
meas tran s_s_3__55 FIND v(n45) AT=0.0001119
meas tran s_co_55 FIND v(n46) AT=0.0001119
meas tran s_s_0__56 FIND v(n18) AT=0.0001139
meas tran s_s_1__56 FIND v(n27) AT=0.0001139
meas tran s_s_2__56 FIND v(n36) AT=0.0001139
meas tran t_s_2__56 WHEN v(n36)=2.5 CROSS=LAST FROM=0.000112 TO=0.000114
meas tran s_s_3__56 FIND v(n45) AT=0.0001139
meas tran s_co_56 FIND v(n46) AT=0.0001139
meas tran s_s_0__57 FIND v(n18) AT=0.0001159
meas tran s_s_1__57 FIND v(n27) AT=0.0001159
meas tran t_s_1__57 WHEN v(n27)=2.5 CROSS=LAST FROM=0.000114 TO=0.000116
meas tran s_s_2__57 FIND v(n36) AT=0.0001159
meas tran t_s_2__57 WHEN v(n36)=2.5 CROSS=LAST FROM=0.000114 TO=0.000116
meas tran s_s_3__57 FIND v(n45) AT=0.0001159
meas tran t_s_3__57 WHEN v(n45)=2.5 CROSS=LAST FROM=0.000114 TO=0.000116
meas tran s_co_57 FIND v(n46) AT=0.0001159
meas tran t_co_57 WHEN v(n46)=2.5 CROSS=LAST FROM=0.000114 TO=0.000116
meas tran s_s_0__58 FIND v(n18) AT=0.0001179
meas tran t_s_0__58 WHEN v(n18)=2.5 CROSS=LAST FROM=0.000116 TO=0.000118
meas tran s_s_1__58 FIND v(n27) AT=0.0001179
meas tran t_s_1__58 WHEN v(n27)=2.5 CROSS=LAST FROM=0.000116 TO=0.000118
meas tran s_s_2__58 FIND v(n36) AT=0.0001179
meas tran t_s_2__58 WHEN v(n36)=2.5 CROSS=LAST FROM=0.000116 TO=0.000118
meas tran s_s_3__58 FIND v(n45) AT=0.0001179
meas tran t_s_3__58 WHEN v(n45)=2.5 CROSS=LAST FROM=0.000116 TO=0.000118
meas tran s_co_58 FIND v(n46) AT=0.0001179
meas tran t_co_58 WHEN v(n46)=2.5 CROSS=LAST FROM=0.000116 TO=0.000118
meas tran s_s_0__59 FIND v(n18) AT=0.0001199
meas tran t_s_0__59 WHEN v(n18)=2.5 CROSS=LAST FROM=0.000118 TO=0.00012
meas tran s_s_1__59 FIND v(n27) AT=0.0001199
meas tran s_s_2__59 FIND v(n36) AT=0.0001199
meas tran t_s_2__59 WHEN v(n36)=2.5 CROSS=LAST FROM=0.000118 TO=0.00012
meas tran s_s_3__59 FIND v(n45) AT=0.0001199
meas tran s_co_59 FIND v(n46) AT=0.0001199
meas tran t_co_59 WHEN v(n46)=2.5 CROSS=LAST FROM=0.000118 TO=0.00012
meas tran s_s_0__60 FIND v(n18) AT=0.0001219
meas tran t_s_0__60 WHEN v(n18)=2.5 CROSS=LAST FROM=0.00012 TO=0.000122
meas tran s_s_1__60 FIND v(n27) AT=0.0001219
meas tran t_s_1__60 WHEN v(n27)=2.5 CROSS=LAST FROM=0.00012 TO=0.000122
meas tran s_s_2__60 FIND v(n36) AT=0.0001219
meas tran s_s_3__60 FIND v(n45) AT=0.0001219
meas tran t_s_3__60 WHEN v(n45)=2.5 CROSS=LAST FROM=0.00012 TO=0.000122
meas tran s_co_60 FIND v(n46) AT=0.0001219
meas tran s_s_0__61 FIND v(n18) AT=0.0001239
meas tran t_s_0__61 WHEN v(n18)=2.5 CROSS=LAST FROM=0.000122 TO=0.000124
meas tran s_s_1__61 FIND v(n27) AT=0.0001239
meas tran t_s_1__61 WHEN v(n27)=2.5 CROSS=LAST FROM=0.000122 TO=0.000124
meas tran s_s_2__61 FIND v(n36) AT=0.0001239
meas tran s_s_3__61 FIND v(n45) AT=0.0001239
meas tran s_co_61 FIND v(n46) AT=0.0001239
meas tran s_s_0__62 FIND v(n18) AT=0.0001259
meas tran s_s_1__62 FIND v(n27) AT=0.0001259
meas tran s_s_2__62 FIND v(n36) AT=0.0001259
meas tran t_s_2__62 WHEN v(n36)=2.5 CROSS=LAST FROM=0.000124 TO=0.000126
meas tran s_s_3__62 FIND v(n45) AT=0.0001259
meas tran t_s_3__62 WHEN v(n45)=2.5 CROSS=LAST FROM=0.000124 TO=0.000126
meas tran s_co_62 FIND v(n46) AT=0.0001259
meas tran t_co_62 WHEN v(n46)=2.5 CROSS=LAST FROM=0.000124 TO=0.000126
meas tran s_s_0__63 FIND v(n18) AT=0.0001279
meas tran s_s_1__63 FIND v(n27) AT=0.0001279
meas tran t_s_1__63 WHEN v(n27)=2.5 CROSS=LAST FROM=0.000126 TO=0.000128
meas tran s_s_2__63 FIND v(n36) AT=0.0001279
meas tran t_s_2__63 WHEN v(n36)=2.5 CROSS=LAST FROM=0.000126 TO=0.000128
meas tran s_s_3__63 FIND v(n45) AT=0.0001279
meas tran s_co_63 FIND v(n46) AT=0.0001279
quit
.endc
.end
