* DLAT — latch D transparente a válvulas termiônicas (4 NOR2 + 1 INV; 9 válvulas JAN-6418)
* família discrete_tube, canto típico (VDD 5 V, 27 °C; modelos TUBE: spice/JAN6418.lib)
* gerado por fr4lane-cellsim --export; rodar: ngspice -b DLAT.cir (imprime as medidas e grava DLAT.dat)
*
* entradas no nível de pior caso: alto = 3.5 V, baixo = 0.4 V; Q leva 4 carga(s) INV.A
* saída: 1 se >= 3 V, 0 se <= 0.6 V
*
* vetores de teste (medida: valor esperado):
*   E ligado até 80 µs; D muda em 20, 40, 60, 100 e 120 µs
*   18 µs (transparente)  ->  s_0: Q=0
*   38 µs (transparente)  ->  s_1: Q=1
*   58 µs (transparente)  ->  s_2: Q=0
*   78 µs (transparente)  ->  s_3: Q=1
*   118 µs (travado)  ->  s_4: Q=1
*   138 µs (travado)  ->  s_5: Q=1
*
* fr4lane-cellsim: canto típico
.temp 27
.param kup=1 kb=1
.param kgm=1.0 kmu=1.0
* Válvula termiônica subminiatura JAN-6418 — modelo Koren / Child-Langmuir para fr4lane-cellsim
*
* Física modelada (ficha técnica Raytheon JAN-6418 em modo de chaveamento / carga espacial):
*   - Lei de Child-Langmuir (potência 3/2) de corrente eletrônica no vácuo entre catodo (k) e
*     placa/anodo (p), controlada pelo potencial da grade (g) com fator de amplificação (mu = 25)
*     e corte em Vgk <= 1,0 V;
*   - Emissão catódica escalada por kgm (simulando variação/envelhecimento de emissão do filamento
*     entre 0,8x no canto lento e 1,25x no canto rápido) e sensibilidade de grade escalada por kmu;
*   - Resistência de escoamento de grade (grid-leak Rgk = 220 kΩ) e condução de grade positiva no vácuo
*     (Dgk com resistência de carga espacial de grade RS = 150 kΩ);
*   - Capacitâncias intereletródicas reais da ficha da JAN-6418:
*       Cgk = 2,8 pF (grade-catodo)
*       Cpk = 2,0 pF (placa-catodo)
*       Cgp = 2,2 pF (capacitância Miller placa-grade)
*
* Pinos na convenção do fr4lane: p (placa/anodo), g (grade de controle), k (catodo/filamento).
.param kgm=1.0 kmu=1.0
.subckt JAN6418 p g k
Cgk g k 2.8p
Cpk p k 2.0p
Cgp p g 2.2p
Rgk g k 220k
Dgk g k DGRID
Bip p k I = kgm * 8.0e-3 * uramp(v(g,k)*kmu - 1.0 + v(p,k)/25.0)^1.5 * tanh(uramp(v(p,k))/0.15)
.model DGRID D(IS=1e-12 N=2.0 RS=150k CJO=0.5p)
.ends JAN6418
.subckt INV A Y VDD GND
RL VDD Y {10000*kup}
R1 A g1 {47000*kb}
XV1 Y g1 GND JAN6418
.ends INV
.subckt NOR2 A B Y VDD GND
RL VDD Y {10000*kup}
R1 A g1 {47000*kb}
R2 B g2 {47000*kb}
XV1 Y g1 GND JAN6418
XV2 Y g2 GND JAN6418
.ends NOR2
.subckt DLAT D E Q VDD GND
X0 E eb VDD GND INV
X1 D eb r VDD GND NOR2
X2 r eb s VDD GND NOR2
X3 r QN Q VDD GND NOR2
X4 s Q QN VDD GND NOR2
.ends DLAT
VDD vdd 0 5
V_E in_E 0 PWL(0 3.5 8e-05 3.5 8.0002e-05 0.4)
V_D in_D 0 PWL(0 0.4 2e-05 0.4 2.0002e-05 3.5 4e-05 3.5 4.0002e-05 0.4 6e-05 0.4 6.0002e-05 3.5 0.0001 3.5 0.000100002 0.4 0.00012 0.4 0.000120002 3.5)
Xdut in_D in_E out_Q vdd 0 DLAT
Xld_out_Q_0 out_Q ld_out_Q_0_Y vdd 0 INV
Xld_out_Q_1 out_Q ld_out_Q_1_Y vdd 0 INV
Xld_out_Q_2 out_Q ld_out_Q_2_Y vdd 0 INV
Xld_out_Q_3 out_Q ld_out_Q_3_Y vdd 0 INV
.tran 4e-08 0.00014
.control
run
linearize
set wr_singlescale
set wr_vecnames
wrdata DLAT.dat v(in_E) v(in_D) v(out_Q)
meas tran s_0 FIND v(out_Q) AT=1.8e-05
meas tran s_1 FIND v(out_Q) AT=3.8e-05
meas tran s_2 FIND v(out_Q) AT=5.8e-05
meas tran s_3 FIND v(out_Q) AT=7.8e-05
meas tran s_4 FIND v(out_Q) AT=0.000118
meas tran s_5 FIND v(out_Q) AT=0.000138
meas tran dq_0 TRIG AT=2e-05 TARG v(out_Q) VAL=1.75 TD=2e-05 CROSS=1
meas tran dq_1 TRIG AT=4e-05 TARG v(out_Q) VAL=1.75 TD=4e-05 CROSS=1
meas tran dq_2 TRIG AT=6e-05 TARG v(out_Q) VAL=1.75 TD=6e-05 CROSS=1
quit
.endc
.end
