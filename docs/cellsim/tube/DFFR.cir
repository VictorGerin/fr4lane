* DFFR — flip-flop D com clear ativo baixo a válvulas termiônicas (3 NOR2 + 3 NOR3 + 2 INV; 17 válvulas JAN-6418)
* família discrete_tube, canto típico (VDD 5 V, 27 °C; modelos TUBE: spice/JAN6418.lib)
* gerado por fr4lane-cellsim --export; rodar: ngspice -b DFFR.cir (imprime as medidas e grava DFFR.dat)
*
* entradas no nível de pior caso: alto = 3.5 V, baixo = 0.4 V; Q leva 4 carga(s) INV.A
* saída: 1 se >= 3 V, 0 se <= 0.6 V
*
* vetores de teste (medida: valor esperado):
*   borda de subida 1 em 20 µs: D=1 (muda 5 µs antes)  ->  q_0: Q=1
*   borda de subida 2 em 40 µs: D=0 (muda 5 µs antes)  ->  q_1: Q=0
*   borda de subida 3 em 60 µs: D=1 (muda 5 µs antes)  ->  q_2: Q=1
*   borda de subida 4 em 80 µs: D=1 (muda 5 µs antes)  ->  q_3: Q=1
*   borda de subida 5 em 100 µs: D=0 (muda 5 µs antes)  ->  q_4: Q=0
*   borda de subida 6 em 120 µs: D=0 (muda 5 µs antes)  ->  q_5: Q=0
*   borda de subida 7 em 140 µs: D=1 (muda 5 µs antes)  ->  q_6: Q=1
*   borda de subida 8 em 160 µs: D=0 (muda 5 µs antes)  ->  q_7: Q=0
*   borda de subida 9 em 180 µs: D=1 (muda 5 µs antes)  ->  q_8: Q=1
*   borda de subida 10 em 200 µs: D=1 (muda 5 µs antes)  ->  q_9: Q=1
*   borda de subida 11 em 220 µs: D=1 (muda 5 µs antes)  ->  q_10: Q=1
*   borda de subida 12 em 240 µs: D=0 (muda 5 µs antes)  ->  q_11: Q=0
*   borda de subida 13 em 260 µs: D=1 (muda 5 µs antes)  ->  q_12: Q=1
*   borda de subida 14 em 280 µs: D=1 (muda 5 µs antes)  ->  q_13: Q=0
*   borda de subida 15 em 300 µs: D=1 (muda 5 µs antes)  ->  q_14: Q=1
*   borda de subida 16 em 320 µs: D=1 (muda 5 µs antes)  ->  q_15: Q=1
*   R = 0 de 270 µs a 296 µs (clear assíncrono, com Q = 1 e D = 1)
*     275 µs, no meio do ciclo  ->  rst_a: Q=0 (muda sem esperar o clock)
*     286 µs, depois da borda 14  ->  rst_b: Q=0 (o clear vence o clock e o dado)
*     borda 15, depois de soltar  ->  q_14: Q=1 (volta a obedecer o dado)
*
* fr4lane-cellsim: canto típico
.temp 27
.param kup=1 kb=1
.param kgm=1.0 kmu=1.0
* Válvula termiônica subminiatura JAN-6418 — modelo Koren / Child-Langmuir para fr4lane-cellsim
*
* Física modelada (ficha técnica Raytheon JAN-6418 em modo de chaveamento / carga espacial):
*   - Lei de Child-Langmuir (potência 3/2) de corrente eletrônica no vácuo entre catodo (k) e
*     placa/anodo (p), controlada pelo potencial da grade (g) com fator de amplificação (mu = 25)
*     e corte em Vgk <= 1,0 V;
*   - Emissão catódica escalada por kgm (simulando variação/envelhecimento de emissão do filamento
*     entre 0,8x no canto lento e 1,25x no canto rápido) e sensibilidade de grade escalada por kmu;
*   - Resistência de escoamento de grade (grid-leak Rgk = 220 kΩ) e condução de grade positiva no vácuo
*     (Dgk com resistência de carga espacial de grade RS = 150 kΩ);
*   - Capacitâncias intereletródicas reais da ficha da JAN-6418:
*       Cgk = 2,8 pF (grade-catodo)
*       Cpk = 2,0 pF (placa-catodo)
*       Cgp = 2,2 pF (capacitância Miller placa-grade)
*
* Pinos na convenção do fr4lane: p (placa/anodo), g (grade de controle), k (catodo/filamento).
.param kgm=1.0 kmu=1.0
.subckt JAN6418 p g k
Cgk g k 2.8p
Cpk p k 2.0p
Cgp p g 2.2p
Rgk g k 220k
Dgk g k DGRID
Bip p k I = kgm * 8.0e-3 * uramp(v(g,k)*kmu - 1.0 + v(p,k)/25.0)^1.5 * tanh(uramp(v(p,k))/0.15)
.model DGRID D(IS=1e-12 N=2.0 RS=150k CJO=0.5p)
.ends JAN6418
.subckt INV A Y VDD GND
RL VDD Y {10000*kup}
R1 A g1 {47000*kb}
XV1 Y g1 GND JAN6418
.ends INV
.subckt NOR3 A B C Y VDD GND
RL VDD Y {10000*kup}
R1 A g1 {47000*kb}
R2 B g2 {47000*kb}
R3 C g3 {47000*kb}
XV1 Y g1 GND JAN6418
XV2 Y g2 GND JAN6418
XV3 Y g3 GND JAN6418
.ends NOR3
.subckt NOR2 A B Y VDD GND
RL VDD Y {10000*kup}
R1 A g1 {47000*kb}
R2 B g2 {47000*kb}
XV1 Y g1 GND JAN6418
XV2 Y g2 GND JAN6418
.ends NOR2
.subckt DFFR D C R Q VDD GND
X0 C ck VDD GND INV
X9 R rn VDD GND INV
X1 rn n4 n2 n1 VDD GND NOR3
X2 n1 ck n2 VDD GND NOR2
X3 n2 ck n4 n3 VDD GND NOR3
X4 n3 D n4 VDD GND NOR2
X5 rn n2 QN Q VDD GND NOR3
X6 Q n3 QN VDD GND NOR2
.ends DFFR
VDD vdd 0 5
V_C in_C 0 PULSE(0.4 3.5 2e-05 2e-09 2e-09 9.998e-06 2e-05)
V_D in_D 0 PWL(0 0.4 1.5e-05 0.4 1.5002e-05 3.5 3.5e-05 3.5 3.5002e-05 0.4 5.5e-05 0.4 5.5002e-05 3.5 9.5e-05 3.5 9.5002e-05 0.4 0.000135 0.4 0.000135002 3.5 0.000155 3.5 0.000155002 0.4 0.000175 0.4 0.000175002 3.5 0.000235 3.5 0.000235002 0.4 0.000255 0.4 0.000255002 3.5)
V_R in_R 0 PWL(0 3.5 0.00027 3.5 0.000270002 0.4 0.000296 0.4 0.000296002 3.5)
Xdut in_D in_C in_R out_Q vdd 0 DFFR
Xld_out_Q_0 out_Q ld_out_Q_0_Y vdd 0 INV
Xld_out_Q_1 out_Q ld_out_Q_1_Y vdd 0 INV
Xld_out_Q_2 out_Q ld_out_Q_2_Y vdd 0 INV
Xld_out_Q_3 out_Q ld_out_Q_3_Y vdd 0 INV
.tran 5e-08 0.000386
.control
run
linearize
set wr_singlescale
set wr_vecnames
wrdata DFFR.dat v(in_C) v(in_D) v(in_R) v(out_Q)
meas tran q_0 FIND v(out_Q) AT=2.9e-05
meas tran q_1 FIND v(out_Q) AT=4.9e-05
meas tran q_2 FIND v(out_Q) AT=6.9e-05
meas tran q_3 FIND v(out_Q) AT=8.9e-05
meas tran q_4 FIND v(out_Q) AT=0.000109
meas tran q_5 FIND v(out_Q) AT=0.000129
meas tran q_6 FIND v(out_Q) AT=0.000149
meas tran q_7 FIND v(out_Q) AT=0.000169
meas tran q_8 FIND v(out_Q) AT=0.000189
meas tran q_9 FIND v(out_Q) AT=0.000209
meas tran q_10 FIND v(out_Q) AT=0.000229
meas tran q_11 FIND v(out_Q) AT=0.000249
meas tran q_12 FIND v(out_Q) AT=0.000269
meas tran q_13 FIND v(out_Q) AT=0.000289
meas tran q_14 FIND v(out_Q) AT=0.000309
meas tran q_15 FIND v(out_Q) AT=0.000329
meas tran rst_a FIND v(out_Q) AT=0.000275
meas tran rst_b FIND v(out_Q) AT=0.000286
quit
.endc
.end
