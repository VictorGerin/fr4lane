* XOR2 — XOR de 2 entradas a válvulas termiônicas (4 NAND2; 8 válvulas JAN-6418)
* família discrete_tube, canto típico (VDD 5 V, 27 °C; modelos TUBE: spice/JAN6418.lib)
* gerado por fr4lane-cellsim --export; rodar: ngspice -b XOR2.cir (imprime as medidas e grava XOR2.dat)
*
* entradas no nível de pior caso: alto = 3.5 V, baixo = 0.4 V; Y leva 4 carga(s) INV.A
* saída: 1 se >= 3 V, 0 se <= 0.6 V
*
* vetores de teste (medida: valor esperado):
*   0-20 µs  A=0 B=0  ->  s_Y_0: Y=0
*   20-40 µs  A=0 B=1  ->  s_Y_1: Y=1
*   40-60 µs  A=1 B=0  ->  s_Y_2: Y=1
*   60-80 µs  A=1 B=1  ->  s_Y_3: Y=0
*   80-100 µs  A=0 B=0  ->  s_Y_4: Y=0
*
* fr4lane-cellsim: canto típico
.temp 27
.param kup=1 kb=1
.param kgm=1.0 kmu=1.0
* Válvula termiônica subminiatura JAN-6418 — modelo Koren / Child-Langmuir para fr4lane-cellsim
*
* Física modelada (ficha técnica Raytheon JAN-6418 em modo de chaveamento / carga espacial):
*   - Lei de Child-Langmuir (potência 3/2) de corrente eletrônica no vácuo entre catodo (k) e
*     placa/anodo (p), controlada pelo potencial da grade (g) com fator de amplificação (mu = 25)
*     e corte em Vgk <= 1,0 V;
*   - Emissão catódica escalada por kgm (simulando variação/envelhecimento de emissão do filamento
*     entre 0,8x no canto lento e 1,25x no canto rápido) e sensibilidade de grade escalada por kmu;
*   - Resistência de escoamento de grade (grid-leak Rgk = 220 kΩ) e condução de grade positiva no vácuo
*     (Dgk com resistência de carga espacial de grade RS = 150 kΩ);
*   - Capacitâncias intereletródicas reais da ficha da JAN-6418:
*       Cgk = 2,8 pF (grade-catodo)
*       Cpk = 2,0 pF (placa-catodo)
*       Cgp = 2,2 pF (capacitância Miller placa-grade)
*
* Pinos na convenção do fr4lane: p (placa/anodo), g (grade de controle), k (catodo/filamento).
.param kgm=1.0 kmu=1.0
.subckt JAN6418 p g k
Cgk g k 2.8p
Cpk p k 2.0p
Cgp p g 2.2p
Rgk g k 220k
Dgk g k DGRID
Bip p k I = kgm * 8.0e-3 * uramp(v(g,k)*kmu - 1.0 + v(p,k)/25.0)^1.5 * tanh(uramp(v(p,k))/0.15)
.model DGRID D(IS=1e-12 N=2.0 RS=150k CJO=0.5p)
.ends JAN6418
.subckt NAND2 A B Y VDD GND
RL VDD Y {10000*kup}
R1 A g1 {47000*kb}
R2 B g2 {47000*kb}
XV1 Y g1 m JAN6418
XV2 m g2 GND JAN6418
.ends NAND2
.subckt XOR2 A B Y VDD GND
X1 A B n1 VDD GND NAND2
X2 A n1 n2 VDD GND NAND2
X3 B n1 n3 VDD GND NAND2
X4 n2 n3 Y VDD GND NAND2
.ends XOR2
.subckt INV A Y VDD GND
RL VDD Y {10000*kup}
R1 A g1 {47000*kb}
XV1 Y g1 GND JAN6418
.ends INV
VDD vdd 0 5
V_A in_A 0 PWL(0 0.4 4e-05 0.4 4.0002e-05 3.5 8e-05 3.5 8.0002e-05 0.4)
V_B in_B 0 PWL(0 0.4 2e-05 0.4 2.0002e-05 3.5 4e-05 3.5 4.0002e-05 0.4 6e-05 0.4 6.0002e-05 3.5 8e-05 3.5 8.0002e-05 0.4)
Xdut in_A in_B out_Y vdd 0 XOR2
Xld_out_Y_0 out_Y ld_out_Y_0_Y vdd 0 INV
Xld_out_Y_1 out_Y ld_out_Y_1_Y vdd 0 INV
Xld_out_Y_2 out_Y ld_out_Y_2_Y vdd 0 INV
Xld_out_Y_3 out_Y ld_out_Y_3_Y vdd 0 INV
.tran 4e-08 0.0001
.control
run
linearize
set wr_singlescale
set wr_vecnames
wrdata XOR2.dat v(in_A) v(in_B) v(out_Y)
meas tran s_Y_0 FIND v(out_Y) AT=1.9e-05
meas tran l_Y_0 FIND v(ld_out_Y_0_Y) AT=1.9e-05
meas tran s_Y_1 FIND v(out_Y) AT=3.9e-05
meas tran l_Y_1 FIND v(ld_out_Y_0_Y) AT=3.9e-05
meas tran d_Y_1 TRIG AT=2e-05 TARG v(out_Y) VAL=1.75 TD=2e-05 CROSS=1
meas tran s_Y_2 FIND v(out_Y) AT=5.9e-05
meas tran l_Y_2 FIND v(ld_out_Y_0_Y) AT=5.9e-05
meas tran s_Y_3 FIND v(out_Y) AT=7.9e-05
meas tran l_Y_3 FIND v(ld_out_Y_0_Y) AT=7.9e-05
meas tran d_Y_3 TRIG AT=6e-05 TARG v(out_Y) VAL=1.75 TD=6e-05 CROSS=1
meas tran s_Y_4 FIND v(out_Y) AT=9.9e-05
meas tran l_Y_4 FIND v(ld_out_Y_0_Y) AT=9.9e-05
quit
.endc
.end
