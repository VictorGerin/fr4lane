* PULLUP — terminação de barramento: pull-up de 1k para o VDD, uma por linha
* família discrete_rtl, canto típico (VDD 5 V, 27 °C; modelos NPN: spice/BC548B.lib)
* gerado por fr4lane-cellsim --export; rodar: ngspice -b PULLUP.cir (imprime as medidas e grava PULLUP.dat)
*
* entradas no nível de pior caso: alto = 1.5 V, baixo = 0.4 V; Y leva 15 carga(s) INV.A
* saída: 1 se >= 1.5 V, 0 se <= 0.5 V
*
* vetores de teste (medida: valor esperado):
*   0-20 µs  (sem entradas)  ->  s_Y_0: Y=1
*   20-40 µs  (sem entradas)  ->  s_Y_1: Y=1
*
* fr4lane-cellsim: canto típico
.temp 27
.param kup=1 kb=1
.model NPN NPN(Is=7.049f Xti=3 Eg=1.11 Vaf=54.76 Bf=250 Ise=78.17f Ne=1.479 Ikf=24.96m Nkf=.5381 Xtb=1.5 Br=1.2 Isc=27.51f Nc=1.775 Ikr=3.321 Rc=.9706 Cjc=4.25p Mjc=.3147 Vjc=.5697 Fc=.5 Cje=11.5p Mje=.6715 Vje=.5 Tr=10n Tf=410.7p Itf=1.12 Xtf=26.19 Vtf=10)
.subckt PULLUP Y VDD GND
R1 VDD Y {1000*kup}
.ends PULLUP
.subckt INV A Y VDD GND
RL VDD Y {1000*kup}
R1 A b1 {10000*kb}
Q1 Y b1 GND NPN
.ends INV
VDD vdd 0 5
Xdut out_Y vdd 0 PULLUP
Xld_out_Y_0 out_Y ld_out_Y_0_Y vdd 0 INV
Xld_out_Y_1 out_Y ld_out_Y_1_Y vdd 0 INV
Xld_out_Y_2 out_Y ld_out_Y_2_Y vdd 0 INV
Xld_out_Y_3 out_Y ld_out_Y_3_Y vdd 0 INV
Xld_out_Y_4 out_Y ld_out_Y_4_Y vdd 0 INV
Xld_out_Y_5 out_Y ld_out_Y_5_Y vdd 0 INV
Xld_out_Y_6 out_Y ld_out_Y_6_Y vdd 0 INV
Xld_out_Y_7 out_Y ld_out_Y_7_Y vdd 0 INV
Xld_out_Y_8 out_Y ld_out_Y_8_Y vdd 0 INV
Xld_out_Y_9 out_Y ld_out_Y_9_Y vdd 0 INV
Xld_out_Y_10 out_Y ld_out_Y_10_Y vdd 0 INV
Xld_out_Y_11 out_Y ld_out_Y_11_Y vdd 0 INV
Xld_out_Y_12 out_Y ld_out_Y_12_Y vdd 0 INV
Xld_out_Y_13 out_Y ld_out_Y_13_Y vdd 0 INV
Xld_out_Y_14 out_Y ld_out_Y_14_Y vdd 0 INV
.tran 4e-08 4e-05
.control
run
linearize
set wr_singlescale
set wr_vecnames
wrdata PULLUP.dat v(out_Y)
meas tran s_Y_0 FIND v(out_Y) AT=1.9e-05
meas tran l_Y_0 FIND v(ld_out_Y_0_Y) AT=1.9e-05
meas tran s_Y_1 FIND v(out_Y) AT=3.9e-05
meas tran l_Y_1 FIND v(ld_out_Y_0_Y) AT=3.9e-05
quit
.endc
.end
