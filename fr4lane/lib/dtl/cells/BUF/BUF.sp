* BUF — buffer DTL (2 INV; 2 transistores NPN)
.subckt BUF A Y VDD GND
X1 A n VDD GND INV
X2 n Y VDD GND INV
.ends BUF
