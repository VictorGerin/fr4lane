* BUF — buffer (dois inversores)
.subckt BUF A Y VDD GND
X1 A  an VDD GND INV
X2 an Y  VDD GND INV
.ends BUF
